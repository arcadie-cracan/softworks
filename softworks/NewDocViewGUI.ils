; Default path helper: delegates to SoftworksDocPathFillFromEnv (Softworks.ils).
; DEBASE GUICellView uses SoftworksDocImportPathResult + ?defValue — no prog2(local setq).
procedure(SoftworksNewDocViewFilePathDefault()
  SoftworksDocPathFillFromEnv()
  SoftworksDocImportPathResult)

; DEBASE: blankstrp may be absent on stripped stacks → eval: not a function - nil.
procedure(SoftworksBlankStringp(s)
  cond(
    ((neq stringp(s) nil) eq(strlen(s) 0))
    ((equal 0 0) nil)))

; Map lib/cell/view name or DEBASE rootType / viewType tag to xlsx|pptx|pdf|html|docx for doc GUI defaults.
procedure(SoftworksNormalizeDocKindTag(tagRaw)
	let(((tag ""))
	  tag = cond(
	    ((neq stringp(tagRaw) nil) tagRaw)
	    ((neq symbolp(tagRaw) nil) sprintf(nil "%s" tagRaw))
	    ((equal 0 0) ""))
	  cond(
	    ((neq tag "") cond(
	      ((neq member(tag '("xlsx" "pptx" "pdf" "html" "docx")) nil) tag)
	      ((neq member(tag '("pdf_view")) nil) "pdf")
	      ((equal 0 0) nil)))
	    ((equal 0 0) nil))))

let((NewDocViewGUI
	   (module_description "The Gui for creating and importing documentation views"))
NewDocViewGUI = let(((SoftworksNdDummy nil)
                    (docViewTypes '("pdf" "pptx" "xlsx" "html" "docx")))

; Shared: launch the external editor for a newly created/imported view.
procedure( launchDocEditor(fp ext)
  cond(
    ((equal ext "xlsx")
     let(((m VrtImport['Softworks]->XLSX))
       cond(((neq procedurep(m->startReader) nil) m->startReader(fp)))))
    ((equal ext "pptx")
     let(((m VrtImport['Softworks]->PPTX))
       cond(((neq procedurep(m->startReader) nil) m->startReader(fp)))))
    ((equal ext "pdf")
     let(((m VrtImport['Softworks]->PDF))
       cond(((neq procedurep(m->startReader) nil) m->startReader(fp)))))
    ((equal ext "html")
     ipcBeginProcess(strcat("firefox " fp) "" nil nil))
    ((equal ext "docx")
     let(((m VrtImport['Softworks]->DOCX))
       cond(((neq procedurep(m->startReader) nil) m->startReader(fp)))))))

; Returns the hiCreateFileSelectorField ?filter string for a given Softworks view type.
; Falls back to a broad document filter for unrecognised types.
procedure( sdmDocExtFilter(viewType)
  case(viewType
    (("pdf")  "PDF Files (*.pdf);;All Files (*)")
    (("pptx") "PowerPoint Files (*.pptx);;All Files (*)")
    (("xlsx") "Excel Files (*.xlsx *.xlsm);;All Files (*)")
    (("html") "HTML Files (*.html *.htm *.hml);;All Files (*)")
    (("docx") "Word Documents (*.docx);;All Files (*)")
    (t        "Document Files (*.pdf *.pptx *.xlsx *.html *.docx);;All Files (*)")))

; "Import to" cyclic callback — enables/disables FileNameField based on mode.
; Existing mode: populate FileNameField from the stored view file name (readonly).
; New cell view: restore editable and default to the source file's basename.
procedure( changeImportModeCB(field scope item)
  progn(
    let(((lib  scope->LibNameField->value)
         (cell scope->CellNameField->value)
         (view scope->ViewNameField->value)
         viewObj)
      if(equal(item "Existing cell view (overwrite)")
        then
          viewObj = ddGetObj(lib cell view nil nil "r")
          scope->FileNameField->value =
            if(viewObj
              then car(reverse(parseString(viewObj~>writePath "/")))
              else "")
          scope->FileNameField->enabled = nil
        else
          scope->FileNameField->value =
            or(car(reverse(parseString(scope->FilePathField->value "/"))) "")
          scope->FileNameField->enabled = t))
    nil))

; ViewNameField callback — validates the view type and auto-selects the dropdown.
;
; Three outcomes based on view name:
;   1. Recognised Softworks doc type AND cell view exists
;        → "Existing cell view (overwrite)", FileNameField = stored file name (readonly),
;          file filter locked to the matching extension.
;   2. Recognised Softworks doc type AND cell view does NOT exist
;        → "New cell view", FileNameField editable,
;          file filter locked to the matching extension.
;   3. Unknown / non-Softworks view type
;        → import locked: both ImportNewDropdown and FilePathField disabled,
;          FileNameField cleared and disabled (import is impossible for this type).
procedure( checkViewExistsCB(field scope)
  let(((lib     scope->LibNameField->value)
       (cell    scope->CellNameField->value)
       (view    field->value)
       isSdmType viewObj)
    when(view != ""
      isSdmType = member(view docViewTypes)
      if(not(isSdmType) then
        ; ── Unrecognised type: lock the form ─────────────────────────────
        scope->ImportNewDropdown->enabled = nil
        scope->FilePathField->enabled     = nil
        scope->FileNameField->value       = ""
        scope->FileNameField->enabled     = nil
      else
        ; ── Recognised Softworks type ────────────────────────────────────
        ; Restore controls and set the type-appropriate file filter.
        scope->ImportNewDropdown->enabled = t
        scope->FilePathField->enabled     = t
        scope->FilePathField->filter      = sdmDocExtFilter(view)
        viewObj = when(lib != "" && cell != ""
          ddGetObj(lib cell view nil nil "r"))
        if(viewObj then
          scope->ImportNewDropdown->value = "Existing cell view (overwrite)"
          scope->FileNameField->value     = car(reverse(parseString(viewObj~>writePath "/")))
          scope->FileNameField->enabled   = nil
        else
          scope->ImportNewDropdown->value = "New cell view"
          scope->FileNameField->value     =
            or(car(reverse(parseString(scope->FilePathField->value "/"))) "")
          scope->FileNameField->enabled   = t))))
  nil)

; Callback for the New Documentation Cell View form (DataTrigger path).
; Creates a blank cell view from a template and launches the editor.
procedure( createViewCB( form )
let((LibName CellName ViewName FileName viewFileObj cpSuccess)
	if( form == nil then
		form = hiGetCurrentForm()
	)
	LibName  = form->LibNameField->value
	CellName = form->CellNameField->value
	ViewName = form->ViewNameField->value
	FileName = form->FileNameField->value

	if(!CheckExtension(FileName)
		error("The file %s does not have a supported file extension" FileName)
	)
	viewFileObj = ddGetObj(LibName CellName ViewName FileName nil "w")
	if(viewFileObj == nil then
		error("Cannot create cell view %s %s %s with file name %s" LibName CellName ViewName FileName)
	)
	let(((templatePath nil) (writePath viewFileObj~>writePath))
	  case(form->ContentsOption->value
		(("Power Point (*.pptx)")
			templatePath = softworksBlankDocTemplatePath("pptx/pptxTemplate.pptx"))
		(("Excel Spreadsheet (*.xlsx)")
			templatePath = softworksBlankDocTemplatePath("xlsx/xlsxTemplate.xlsx"))
		(("PDF (*.pdf)")
			templatePath = softworksBlankDocTemplatePath("pdf/pdfTemplate.pdf"))
		(("HTML (*.html)")
			templatePath = softworksBlankDocTemplatePath("html/htmlTemplate.html"))
		(("Word Document (*.docx)")
			templatePath = softworksBlankDocTemplatePath("docx/docxTemplate.docx"))
	  )
	  let(((sourcePath templatePath))
	    cond(
		  ((neq isReadable(templatePath) t)
		   warn("Softworks: template %s not found; falling back to built-in template." templatePath)
		   sourcePath = strcat(SoftworksInstallDir "/templates/" car(reverse(parseString(templatePath "/"))))))
	    cpSuccess = shell(strcat("cp -f " EscapeSpecialCharacters(sourcePath) " " EscapeSpecialCharacters(writePath)))
	    if(not(cpSuccess) then
		  error("The file copy failed.  Could not copy template %s to %s" sourcePath writePath)
	    else
		  printf("Created %s %s %s cell view from template %s\n" LibName CellName ViewName sourcePath)
	    )
	  )
	)
	ddUpdateLibList()
	hiSetCallbackStatus(form t)
	hiFormUnmap(form)
	cond(
	  ((neq cpSuccess nil)
	   launchDocEditor(viewFileObj~>writePath car(reverse(parseString(FileName "."))))))
))

; Callback for the Import Document as Cell View form (Library Manager path).
; Both modes copy from the selected source file; the only difference is whether
; the target cell view already exists (prompts to overwrite) or is brand new.
procedure( createViewFromFileCB( form )
let((LibName CellName ViewName FileName FilePath viewFileObj overwrite cpSuccess mode)
	if( form == nil then
		form = hiGetCurrentForm()
	)
	LibName  = form->LibNameField->value
	CellName = form->CellNameField->value
	ViewName = form->ViewNameField->value
	FilePath = form->FilePathField->value
	FileName = form->FileNameField->value
	mode     = form->ImportNewDropdown->value
	; Reject non-Softworks view types early — the form should have prevented this
	; via checkViewExistsCB, but guard here as a belt-and-suspenders check.
	unless(member(ViewName docViewTypes)
		error("Cannot import: view type '%s' is not a registered Softworks document type (supported: %s)"
		      ViewName buildString(docViewTypes ", ")))
	; Default file name to source basename when FileNameField is left blank.
	cond(
	  ((neq SoftworksBlankStringp(FileName) nil)
	   FileName = car(reverse(parseString(FilePath "/")))))
	if(!CheckExtension(FileName)
		error("The file %s does not have a supported file extension" FileName)
	)
	if(equal(mode "Existing cell view (overwrite)") then
		; ── Overwrite existing ───────────────────────────────────────────
		viewFileObj = ddGetObj(LibName CellName ViewName nil nil "r")
		if( viewFileObj then
			overwrite = hiDisplayAppDBox(
				?name 'OverwriteDBox
				?dboxBanner "Overwrite Existing Cell View?"
				?dboxText strcat("Do you want to overwrite the following existing cell view?\nLib: " LibName "\nCell: " CellName "\nView: " ViewName)
				)
			when(overwrite && ddNeedCheckout(viewFileObj)
				ddCheckout(viewFileObj))
		else
			overwrite = t  ; view no longer exists — create it anyway
		)
	else
		; ── New cell view ────────────────────────────────────────────────
		overwrite = t
	) ; if mode
	when(overwrite
		viewFileObj = ddGetObj(LibName CellName ViewName FileName nil "w")
		cpSuccess = shell(strcat("cp -f " EscapeSpecialCharacters(FilePath) " " viewFileObj~>writePath))
		if(not(cpSuccess) then
			error("The file copy failed.  Could not copy %s to %s" EscapeSpecialCharacters(FilePath) viewFileObj~>writePath)
		else
			printf("Imported %s as %s %s %s cell view\n" FilePath LibName CellName ViewName)
		)
	)
	ddUpdateLibList()
	hiSetCallbackStatus(form t)
	hiFormUnmap(form)
	cond(
	  ((neq cpSuccess nil)
	   launchDocEditor(viewFileObj~>writePath car(reverse(parseString(FileName "."))))))
))

; DataTrigger path: open when view doesn't exist — New cell view only.
procedure( CombinedGUI(LibSelected CellSelected ViewSelected @optional RootTypeHint)
let((SelectionL newForm formName)
	SoftworksDocPathFillFromEnv()
	SelectionL = GUICellView(LibSelected CellSelected ViewSelected RootTypeHint)
	formName = gensym('newDocViewForm)
	newForm = hiCreateAppForm(
		?name formName
		?formTitle "New Documentation Cell View"
		?fields car(SelectionL)
		?buttonLayout 'OKCancelApply
		?callback createViewCB
		?unmapAfterCB t
	)
	hiInstantiateForm(newForm)
	; Link only Lib→Cell; ViewNameField is free-text (allowAny) and must keep ViewSelected.
	ddHiLinkFields(
		newForm->LibNameField
		newForm->CellNameField
	)
	hiDisplayForm( newForm )
	nil
))

; Library Manager path: import an existing file into either an existing or new cell view.
procedure( CreateViewFromFileGUI(@optional (LibSelected "") (CellSelected "") (ViewSelected ""))
let((SelectionL newForm formName existingViewObj isSdmType initialMode initialFileName
     initialFileNameEnabled initialFilter)
	SoftworksDocPathFillFromEnv()
	isSdmType = member(ViewSelected docViewTypes)
	; Determine initial mode by checking whether the pre-selected cell view exists.
	existingViewObj = nil
	when(LibSelected != "" && CellSelected != "" && ViewSelected != ""
		existingViewObj = ddGetObj(LibSelected CellSelected ViewSelected nil nil "r"))
	; Block the form entirely when the pre-selected view exists but is not a Softworks
	; doc type — importing into it would corrupt it.
	; (A non-existent view with an unrecognised name is still allowed: checkViewExistsCB
	;  will lock the controls if the user types an unsupported view name.)
	if(existingViewObj && not(isSdmType) then
		warn("[Softworks] Cannot import into %s / %s / %s: '%s' is not a registered Softworks document view type."
		     LibSelected CellSelected ViewSelected ViewSelected)
		nil
	else
		initialMode            = if(existingViewObj then "Existing cell view (overwrite)" else "New cell view")
		initialFileName        = if(existingViewObj then car(reverse(parseString(existingViewObj~>writePath "/"))) else "")
		initialFileNameEnabled = not(existingViewObj)
		initialFilter          = sdmDocExtFilter(ViewSelected)
		SelectionL = nil
		SelectionL = tconc(SelectionL list(ddHiCreateLibraryComboField(
			?name       'LibNameField
			?prompt     "Library"
			?defValue    LibSelected
			?toolTip    "Library Name"
			?validationType  'allowExisting
			?editable  t)
			5:10 400:30 60))
		SelectionL = tconc(SelectionL list(ddHiCreateCellComboField(
			?name      'CellNameField
			?prompt    "Cell"
			?defValue   CellSelected
			?toolTip    "Cell Name"
			?validationType  'allowAny
			?editable    t)
			5:50 400:30 60))
		; checkViewExistsCB auto-selects the dropdown and locks/unlocks controls
		; whenever the view name resolves to a known Softworks type.
		SelectionL = tconc(SelectionL list(ddHiCreateViewComboField(
			?name      'ViewNameField
			?prompt    "View"
			?defValue  ViewSelected
			?toolTip       "View Name"
			?validationType  'allowAny
			?callback  checkViewExistsCB
			?editable   t)
			5:90 400:30 60))
		SelectionL = tconc(SelectionL list(hiCreateCyclicField(
			?name      'ImportNewDropdown
			?choices   '("Existing cell view (overwrite)" "New cell view")
			?defValue  initialMode
			?prompt    "Import to"
			?callback  changeImportModeCB
			?keepHistory t)
			5:130 400:30 90))
		; File filter is type-appropriate at open time; checkViewExistsCB updates it
		; dynamically when the user changes the view name.
		SelectionL = tconc(SelectionL list(hiCreateFileSelectorField(
			?name     'FilePathField
			?mode     'existingFile
			?prompt   "Source File"
			?defValue  SoftworksDocImportPathResult
			?filter    initialFilter
			?editable  t)
			5:170 400:30 100))
		; FileNameField is disabled when overwriting an existing view (auto-filled
		; from the stored file name); editable when creating a new view.
		SelectionL = tconc(SelectionL list(hiCreateStringField(
			?name      'FileNameField
			?prompt    "File Name"
			?defValue  initialFileName
			?toolTip   "Auto-filled when overwriting an existing view; editable for new views (blank = use source file name)"
			?modifyCallback CheckFileName
			?editable  t
			?enabled   initialFileNameEnabled)
			5:210 400:30 100))
		formName = gensym('importFileDocForm)
		newForm = hiCreateAppForm(
			?name formName
			?formTitle "Import Document as Cell View"
			?fields car(SelectionL)
			?buttonLayout 'OKCancelApply
			?callback createViewFromFileCB
			?unmapAfterCB t
		)
		hiInstantiateForm(newForm)
		ddHiLinkFields(
			newForm->LibNameField
			newForm->CellNameField
		)
		newForm->ViewNameField->value = ViewSelected
		hiDisplayForm( newForm )
		nil
	) ; if existingViewObj && not(isSdmType)
))

; Build the New-view form fields (used by CombinedGUI).
procedure( GUICellView(LibSelected CellSelected ViewSelected @optional RootTypeHint)
  let((SelectionL viewTag viewDocKind docKind unknownDocKind contentsDef fileNameDef)
	SelectionL = nil
	viewTag = cond(
	  ((neq stringp(ViewSelected) nil) ViewSelected)
	  ((neq symbolp(ViewSelected) nil) sprintf(nil "%s" ViewSelected))
	  ((equal 0 0) ""))
	viewDocKind = SoftworksNormalizeDocKindTag(viewTag)
	docKind = cond(
	  ((neq viewDocKind nil) viewDocKind)
	  ((equal 0 0) SoftworksNormalizeDocKindTag(RootTypeHint)))
	unknownDocKind = nil
	cond(
	  ((eq docKind nil) unknownDocKind = 'SoftworksUnknownDocKind)
	  ((neq SoftworksBlankStringp(docKind) nil) unknownDocKind = 'SoftworksUnknownDocKind))
	contentsDef = cond(
	  ((neq unknownDocKind nil) "Power Point (*.pptx)")
	  ((neq member(docKind '("xlsx")) nil) "Excel Spreadsheet (*.xlsx)")
	  ((neq member(docKind '("pptx")) nil) "Power Point (*.pptx)")
	  ((neq member(docKind '("pdf")) nil) "PDF (*.pdf)")
	  ((neq member(docKind '("html")) nil) "HTML (*.html)")
	  ((neq member(docKind '("docx")) nil) "Word Document (*.docx)")
	  ((equal 0 0) "Power Point (*.pptx)"))
	fileNameDef = cond(
	  ((neq unknownDocKind nil) "Review.pptx")
	  ((neq member(docKind '("xlsx")) nil)
	    cond(
	      ((neq member(viewTag '("xlsx")) nil) "Review.xlsx")
	      ((equal 0 0) sprintf(nil "%s.xlsx" viewTag))))
	  ((neq member(docKind '("pptx")) nil)
	    cond(
	      ((neq member(viewTag '("pptx")) nil) "Review.pptx")
	      ((equal 0 0) sprintf(nil "%s.pptx" viewTag))))
	  ((neq member(docKind '("pdf")) nil)
	    cond(
	      ((neq member(viewTag '("pdf")) nil) "Review.pdf")
	      ((neq member(viewTag '("pdf_view")) nil) "Review.pdf")
	      ((equal 0 0) sprintf(nil "%s.pdf" viewTag))))
	  ((neq member(docKind '("html")) nil)
	    cond(
	      ((neq member(viewTag '("html")) nil) "Review.html")
	      ((equal 0 0) sprintf(nil "%s.html" viewTag))))
	  ((neq member(docKind '("docx")) nil)
	    cond(
	      ((neq member(viewTag '("docx")) nil) "Review.docx")
	      ((equal 0 0) sprintf(nil "%s.docx" viewTag))))
	  ((equal 0 0) "Review.pptx"))
	; LIB, CELL, VIEW SELECTION
	SelectionL = tconc(SelectionL list(ddHiCreateLibraryComboField(
		?name       'LibNameField
		?prompt     "Library"
		?defValue    LibSelected
		?toolTip    "Library Name"
		?validationType  'allowExisting
		?editable  t)
		5:10 400:30 60))
	SelectionL = tconc(SelectionL list(ddHiCreateCellComboField(
		?name      'CellNameField
		?prompt    "Cell"
		?defValue   CellSelected
		?toolTip    "Cell Name"
		?validationType  'allowAny
		?editable    t)
		5:50 400:30 60))
	SelectionL = tconc(SelectionL list(ddHiCreateViewComboField(
		?name      'ViewNameField
		?prompt    "View"
		?defValue  ViewSelected
		?toolTip       "View Name"
		?validationType  'allowAny
		?editable   t)
		5:90 400:30 60))
	SelectionL = tconc(SelectionL list(hiCreateStringField(
		?name      'FileNameField
		?prompt    "File Name"
		?defValue  fileNameDef
		?modifyCallback CheckFileName
		?editable  t
		?enabled   t)
		5:130 400:30 100))
	SelectionL = tconc(SelectionL list(hiCreateCyclicField(
		?name       'ContentsOption
		?choices    '("Power Point (*.pptx)" "Excel Spreadsheet (*.xlsx)" "PDF (*.pdf)" "HTML (*.html)" "Word Document (*.docx)")
		?defValue   contentsDef
		?callback   UpdateFileContents
		?prompt     "File Type"
		?enabled   t
		?keepHistory t)
		5:170 400:30 100))
	SelectionL
))

; Update the file name to work nicely with Unix
procedure( CheckFileName(_field _scope t_latestTextValue _g_sourceOfChange)
let( (comPat1 comPat2 comPat3 out)
	comPat1 = pcreCompile( " " )
	out = pcreReplace( comPat1 t_latestTextValue "_" 0 )
	comPat2 = pcreCompile( "[^A-Z^a-z^0-9^_^\\.]+" )
	out = pcreReplace( comPat2 out "" 0 )
	comPat3 = pcreCompile( "[\\^]" )
	out = pcreReplace( comPat3 out "" 0 )
	out
))

procedure( CheckExtension(file)
	strcmp(substring(file -5) ".pptx") ||
	strcmp(substring(file -4) ".pdf") ||
	strcmp(substring(file -5) ".xlsx") ||
	strcmp(substring(file -5) ".xlsm") ||
	strcmp(substring(file -4) ".mdf") ||
	strcmp(substring(file -4) ".txt") ||
	strcmp(substring(file -4) ".hml") ||
	strcmp(substring(file -5) ".html") ||
	strcmp(substring(file -5) ".docx")
)

procedure( EscapeSpecialCharacters(t_fileName)
let( (comPat1 comPat2 comPat3 out)
	comPat1 = pcreCompile( " " )
	out = pcreReplace( comPat1 t_fileName "\\\\ " 0 )
	comPat2 = pcreCompile( "\\&" )
	out = pcreReplace( comPat2 out "\\& " 0 )
	comPat3 = pcreCompile( "\\*" )
	out = pcreReplace( comPat3 out "\\* " 0 )
))

; HI treats cyclic ?callback return as callable — progn forces nil result.
procedure( UpdateFileContents(_field scope item)
	progn(
	  case(item
		(("Power Point (*.pptx)")
		 scope->FileNameField->value = strcat(buildString(reverse(cdr(reverse(parseString(scope->FileNameField->value ".")))) "") ".pptx"))
		(("Excel Spreadsheet (*.xlsx)")
		 scope->FileNameField->value = strcat(buildString(reverse(cdr(reverse(parseString(scope->FileNameField->value ".")))) "") ".xlsx"))
		(("PDF (*.pdf)")
		 scope->FileNameField->value = strcat(buildString(reverse(cdr(reverse(parseString(scope->FileNameField->value ".")))) "") ".pdf"))
		(("HTML (*.html)")
		 scope->FileNameField->value = strcat(buildString(reverse(cdr(reverse(parseString(scope->FileNameField->value ".")))) "") ".html"))
		(("Word Document (*.docx)")
		 scope->FileNameField->value = strcat(buildString(reverse(cdr(reverse(parseString(scope->FileNameField->value ".")))) "") ".docx"))
	  )
	  nil))

list(nil
	'CombinedGUI CombinedGUI
	'CreateViewFromFileGUI CreateViewFromFileGUI
	'changeImportModeCB changeImportModeCB
	'checkViewExistsCB checkViewExistsCB
))

putprop(VrtImport['Softworks] NewDocViewGUI 'NewDocViewGUI)
)
; Must be *outside* the package let: assigning inside the let can leave these
; scoped to the let, so SdmXLSX and lmgrCreateMenuItem callbacks cannot see them.
SdmCombinedGUI = VrtImport['Softworks]->NewDocViewGUI->CombinedGUI

; ddsLMCMenuItem prepends the menu-item action ID as the first argument before
; spreading the lib/cell/view selection context, giving 6 args total:
;   LMgr path:    ("ImportDocAsView" lib cell view "" "")
;   Direct path:  (lib cell view)
; The action ID is the sentinel: when arg1 matches it we shift the window by 1.
procedure( SdmCreateViewFromFileGUI(@rest args)
  let(((fn VrtImport['Softworks]->NewDocViewGUI->CreateViewFromFileGUI)
       (a1 or(car(args)    ""))
       (a2 or(cadr(args)   ""))
       (a3 or(caddr(args)  ""))
       (a4 or(cadddr(args) "")))
    if(equal(a1 "ImportDocAsView")
      then fn(a2 a3 a4)
      else fn(a1 a2 a3))))
