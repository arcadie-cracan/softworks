; Tracing: SOFTWORKS_GUI_TRACE=1, or SOFTWORKS_TRIGGER_TRACE, or SOFTWORKS_DEBUG=1
procedure(SoftworksNewDocViewTraceP()
  or(
    getShellEnvVar("SOFTWORKS_GUI_TRACE")
    getShellEnvVar("SOFTWORKS_TRIGGER_TRACE")
    getShellEnvVar("SOFTWORKS_DEBUG")))

; Default path for ?defValue: delegate to SoftworksInvokeProjectDocDir (builtins only;
; does not call softworksProjectDocDir / d() — those can still be "not a function - nil"
; under HI / SKILL++).
procedure(SoftworksNewDocViewFilePathDefault()
  progn(
    when(SoftworksNewDocViewTraceP()
      warn(
        "[Softworks GUI] defValue path: SoftworksInvokeProjectDocDir (env + pwd, builtins only)"))
    SoftworksInvokeProjectDocDir()
  )
)

; Map lib/cell/view name or DEBASE rootType / viewType tag to xlsx|pptx|pdf|html for doc GUI defaults.
procedure(SoftworksNormalizeDocKindTag(tagRaw)
	let((tag cond((stringp(tagRaw)) tagRaw) ((symbolp(tagRaw)) sprintf(nil "%s" tagRaw)) (t "")))
	  if(blankstrp(tag) then nil
	  else cond(
	    ((member(tag '("xlsx" "pptx" "pdf" "html"))) tag)
	    ((zerop(strcmp(tag "pdf_view"))) "pdf")
	    (t nil))))

let((NewDocViewGUI
	   (module_description "The Gui for creating and importing documentation views"))
NewDocViewGUI = let(((SoftworksNdDummy nil)))

; Imports an existing documentation file. (PPTX, PDF, Excel)  Main callback for the form.
;procedure( importDocCB(o_field form g_item)
procedure( importDocCB( form )
let((LibName CellName ViewName FileName viewFileObj overwrite cpSuccess fileSourceDescription form)
	if( form == nil then
		form = hiGetCurrentForm()
	) ; if
	LibName  = form->LibNameField->value
	CellName = form->CellNameField->value
	ViewName = form->ViewNameField->value
	FileName = form->FileNameField->value

	if(!CheckExtension(FileName)
		error("The file %s does not have a supported file extension" FileName)
	)
	if( form->ImportNewDropdown->value == "Import" then
		viewFileObj = ddGetObj(LibName CellName ViewName nil nil "r")
		if( viewFileObj then
			overwrite = hiDisplayAppDBox(
				?name 'OverwriteDBox
				?dboxBanner "Overwrite Existing Cellview?"
				?dboxText strcat("Do you want to overwrite the following existing cell view?\nLib: " LibName "\nCell: " CellName "\nView: " ViewName)
				)
			when(overwrite && ddNeedCheckout(viewFileObj)
				ddCheckout(viewFileObj))
		else
			overwrite = t ;Cell doesn't exist yet
		) ;if
		when(overwrite
		;Create the view
			viewFileObj=ddGetObj(LibName CellName ViewName FileName nil "w")
			cpSuccess = fileSourceDescription = sprintf(nil "Imported from %s" form->FilePathField->value)
			shell(strcat("cp -f " EscapeSpecialCharacters(form->FilePathField->value) " " viewFileObj~>writePath)) ; Import the selected file
			if(not(cpSuccess) then
				error("The file copy failed.  Could not copy from %s to %s" EscapeSpecialCharacters(form->FilePathField->value) viewFileObj~>writePath)
			else
				printf("Created %s %s %s cell view %s" LibName CellName ViewName fileSourceDescription)
			) ; if
		) ;when
	else
		viewFileObj=ddGetObj(LibName CellName ViewName FileName nil "w")
		cpSuccess = fileSourceDescription = sprintf(nil "New cell created from %s" form->FilePathField->value)
		case(form->ContentsOption->value
			(("Power Point (*.pptx)")
				;shell(strcat("cp -f " getShellEnvVar("SkyVerTemplatePath") "DesignTemplate.pptx " viewFileObj~>writePath))) ; Copy blank skyworks template presentation
				; system(sprintf(nil "cp $SOFTWORKS_ROOT/src/skill/%s %s" templateName file))
				shell(strcat("cp -f " EscapeSpecialCharacters(softworksBlankDocTemplatePath("pptx/pptxTemplate.pptx")) " " viewFileObj~>writePath)))
			(("Excel Spreadsheet (*.xlsx)")
				shell(strcat("cp -f " EscapeSpecialCharacters(softworksBlankDocTemplatePath("xlsx/xlsxTemplate.xlsx")) " " viewFileObj~>writePath)))
			(("PDF (*.pdf)")
				shell(strcat("cp -f " EscapeSpecialCharacters(softworksBlankDocTemplatePath("pdf/pdfTemplate.pdf")) " " viewFileObj~>writePath)))
			(("HTML (*.html)")
				shell(strcat("cp -f " EscapeSpecialCharacters(softworksBlankDocTemplatePath("html/htmlTemplate.html")) " " viewFileObj~>writePath)))
		)
		if(not(cpSuccess) then
			error("The file copy failed.  Could not copy from %s to %s" EscapeSpecialCharacters(form->FilePathField->value) viewFileObj~>writePath)
		else
			printf("Created %s %s %s cell view %s" LibName CellName ViewName fileSourceDescription)
		)
	) ; if statement for import / new cell view
	ddUpdateLibList() ; Update library list
	hiSetCallbackStatus(form t)
	hiFormUnmap(form)
)
)

; Choose between import or new cell
procedure( CombinedGUI(LibSelected CellSelected ViewSelected @optional RootTypeHint)
let((SelectionL newForm formName)
	when(SoftworksNewDocViewTraceP()
	  warn(sprintf(nil
	    "[Softworks GUI] CombinedGUI: enter lib=%L cell=%L view=%L rootTypeHint=%L"
	    LibSelected CellSelected ViewSelected RootTypeHint)))
	SelectionL = GUICellView(LibSelected CellSelected ViewSelected RootTypeHint)
	when(SoftworksNewDocViewTraceP()
	  warn(sprintf(nil
	    "[Softworks GUI] CombinedGUI: GUICellView returned, SelectionL car=%L" car(SelectionL))))
    ; CREATE FORM
	formName = gensym('importGUIDocForm)
	when(SoftworksNewDocViewTraceP()
	  warn("[Softworks GUI] CombinedGUI: about to hiCreateAppForm + hiDisplayForm"))
	newForm = hiCreateAppForm(
		?name formName
		?formTitle "Documentation Cell View"
		?fields car(SelectionL)
		?buttonLayout 'OKCancelApply
		?callback	importDocCB
;		?formType 'nonOptions
		?unmapAfterCB t
	)
	putprop(formName "skyOpenSkyVerHelp()" 'hiHelpAction)
	hiInstantiateForm(newForm)
	ddHiLinkFields(
		newForm->LibNameField
		newForm->CellNameField
		newForm->ViewNameField
	)
	hiDisplayForm( newForm )
))

; Create basic GUI with button for import or new view
procedure( GUICellView(LibSelected CellSelected ViewSelected @optional RootTypeHint)
  let((SelectionL defaultImportPath viewTag docKind docIntentFlag importNewDef contentsDef
	filePathInvisible contentsInvisible fileNameDef)
	viewTag = cond(
	  ((stringp(ViewSelected)) ViewSelected)
	  ((symbolp(ViewSelected)) sprintf(nil "%s" ViewSelected))
	  (t ""))
	docKind = or(SoftworksNormalizeDocKindTag(viewTag) SoftworksNormalizeDocKindTag(RootTypeHint))
	docIntentFlag = not(not(docKind))
	importNewDef = if(docIntentFlag then "New" else "Import")
	contentsDef = cond(
	  ((not(docIntentFlag)) "Power Point (*.pptx)")
	  ((zerop(strcmp(docKind "xlsx"))) "Excel Spreadsheet (*.xlsx)")
	  ((zerop(strcmp(docKind "pptx"))) "Power Point (*.pptx)")
	  ((zerop(strcmp(docKind "pdf"))) "PDF (*.pdf)")
	  ((zerop(strcmp(docKind "html"))) "HTML (*.html)")
	  (t "Power Point (*.pptx)"))
	filePathInvisible = docIntentFlag
	contentsInvisible = not(docIntentFlag)
	fileNameDef = cond(
	  ((not(docIntentFlag)) "Review.pptx")
	  ((zerop(strcmp(docKind "xlsx"))) if(zerop(strcmp(viewTag "xlsx")) "Review.xlsx" strcat(viewTag ".xlsx")))
	  ((zerop(strcmp(docKind "pptx"))) if(zerop(strcmp(viewTag "pptx")) "Review.pptx" strcat(viewTag ".pptx")))
	  ((zerop(strcmp(docKind "pdf")))
	    if(or(zerop(strcmp(viewTag "pdf")) zerop(strcmp(viewTag "pdf_view"))) "Review.pdf" strcat(viewTag ".pdf")))
	  ((zerop(strcmp(docKind "html"))) if(zerop(strcmp(viewTag "html")) "Review.html" strcat(viewTag ".html")))
	  (t "Review.pptx"))
	when(SoftworksNewDocViewTraceP()
	  warn(sprintf(nil
	    "[Softworks GUI] GUICellView: enter lib=%L cell=%L view=%L rootHint=%L viewTag=%L docKind=%L docIntentFlag=%L importNewDef=%L"
	    LibSelected CellSelected ViewSelected RootTypeHint viewTag docKind docIntentFlag importNewDef)))
	defaultImportPath = SoftworksNewDocViewFilePathDefault()
	; LIB, CELL, VIEW SELECTION
	SelectionL = tconc(SelectionL list(ddHiCreateLibraryComboField(
		?name       'LibNameField
		?prompt     "Library"
		?defValue    LibSelected
		?toolTip	"Library Name"
		?validationType	 'allowExisting
	    ?editable  t)
		5:10 400:30 60))
	when(SoftworksNewDocViewTraceP()
	  warn("[Softworks GUI] GUICellView: after ddHiCreateLibraryComboField"))
	SelectionL = tconc(SelectionL list(ddHiCreateCellComboField(
		?name      'CellNameField
	    ?prompt    "Cell"
	    ?defValue   CellSelected
		?toolTip	"Cell Name"
		?validationType	 'allowAny
	    ?editable    t)
		5:50 400:30 60))
	SelectionL = tconc(SelectionL list(ddHiCreateViewComboField(
		?name      'ViewNameField
	    ?prompt    "View"
	    ?defValue  ViewSelected
		?toolTip	   "View Name"
		?validationType	 'allowAny
	    ?editable   t)
		5:90 400:30 60))
	when(SoftworksNewDocViewTraceP()
	  warn("[Softworks GUI] GUICellView: after view combo, before ImportNewDropdown"))
	SelectionL = tconc(SelectionL list(hiCreateCyclicField(
		?name      'ImportNewDropdown
		?choices   '("Import" "New")
		?defValue  importNewDef
		?prompt    "Type of Cell:"
		?callback   changeViewToImport
		?keepHistory t)
		5:130 400:30 90))
	when(SoftworksNewDocViewTraceP()
	  warn("[Softworks GUI] GUICellView: before file path field (defValue -> SoftworksNewDocViewFilePathDefault)"))
	; Import Cell View (Default). No ?modifyCallback: DEBASE can apply the callback return as a
	; function (errors like not a function - t or - "/path/"). Set file name in FileNameField.
	SelectionL = tconc(SelectionL list(hiCreateFileSelectorField(
		?name     'FilePathField
		?mode     'existingFile
		?prompt   "Import File Path"
		?defValue  defaultImportPath
		?invisible filePathInvisible
		?editable  t)
		5:170 400:30 100))
	when(SoftworksNewDocViewTraceP()
	  warn("[Softworks GUI] GUICellView: after file path field (defValue callback completed)"))
	SelectionL = tconc(SelectionL list(hiCreateStringField(
		?name      'FileNameField
	  ?prompt    "File Name"
	  ?defValue  fileNameDef
		?modifyCallback CheckFileName
	  ?editable  t
		?enabled   t)
		5:210 400:30 100))

	; New Cell View
	SelectionL = tconc(SelectionL list(hiCreateCyclicField(
		?name       'ContentsOption
		?choices    '("Power Point (*.pptx)" "Excel Spreadsheet (*.xlsx)" "PDF (*.pdf)" "HTML (*.html)")
		?defValue   contentsDef
		?callback   UpdateFileContents
		?prompt     "File Type"
		?invisible  contentsInvisible
		?enabled   t
		?keepHistory t)
		5:170 400:30 100))
	when(SoftworksNewDocViewTraceP()
	  warn("[Softworks GUI] GUICellView: after ContentsOption; returning field list to CombinedGUI"))
	SelectionL
))

; Adjust GUI options for either New cell or Import cell formats
; HI treats cyclic ?callback return as a callable — assignments return t in SKILL; end with nil.
procedure( changeViewToImport( o_field g_scope g_item )
	if( (g_item == "New")
		then
			g_scope->FilePathField->invisible = t
			g_scope->ContentsOption->invisible = nil
			;hiUpdateFormBlock( g_scope )
		else
			g_scope->ContentsOption->invisible = t
			g_scope->FilePathField->invisible = nil
			;hiUpdateFormBlock( g_scope )
;			hiChangeFormCallback( form newDocCB)
	) ; if
	nil
) ;procedure

; Update the file name to work nicely with Unix
procedure( CheckFileName(_field _scope t_latestTextValue _g_sourceOfChange)
let( (comPat1 comPat2  comPat2 out)
	; replaces spaces with underscores
	comPat1 = pcreCompile( " " )
	out = pcreReplace( comPat1 t_latestTextValue "_" 0 )
	; Keeps the user from entering the following special characters: * / > < : [ ] | ( ) ; # @ ! $ ^ -
	;comPat2 = pcreCompile( "[\\*/><:&\\[\\]\\|();#@!\\$%\\^\\-]" )
	;pcreReplace( comPat2 out "" 0 )
	; Only allow alphanumeric characters, "."" and "_"
	comPat2 = pcreCompile( "[^A-Z^a-z^0-9^_^\\.]+" )
	out = pcreReplace( comPat2 out "" 0 )
  comPat3 = pcreCompile( "[\\^]" )
	out = pcreReplace( comPat3 out "" 0 )
  out
))

procedure( CheckExtension(file)
	strcmp(substring(file -5) ".pptx") ||
	strcmp(substring(file -4) ".pdf") ||
	strcmp(substring(file -5) ".xlsx") ||
	strcmp(substring(file -5) ".xlsm") ||
	strcmp(substring(file -4) ".mdf") ||
	strcmp(substring(file -4) ".txt") ||
	strcmp(substring(file -4) ".hml") ||
	strcmp(substring(file -5) ".html")
)

procedure( EscapeSpecialCharacters(t_fileName)
let( (comPat1 comPat2 comPat3 out)
	; escape spaces
	comPat1 = pcreCompile( " " )
	out = pcreReplace( comPat1 t_fileName "\\\\ " 0 )
	; escape &
	comPat2 = pcreCompile( "\\&" )
	out = pcreReplace( comPat2 out "\\& " 0 )
	; escape *
	comPat3 = pcreCompile( "\\*" )
	out = pcreReplace( comPat3 out "\\* " 0 )
))

; Changes FileNameField extension based on drop down menu
; HI treats cyclic ?callback return as a callable — case branches end with assignments (-> t); return nil.
procedure( UpdateFileContents(_field scope item)
   case(item
		(("Power Point (*.pptx)")
		 scope->FileNameField->value = strcat(buildString(reverse(cdr(reverse(parseString(scope->FileNameField->value ".")))) "") ".pptx")
		 scope->ViewNameField->value = "pptx")
		(("Excel Spreadsheet (*.xlsx)")
		 scope->FileNameField->value = strcat(buildString(reverse(cdr(reverse(parseString(scope->FileNameField->value ".")))) "") ".xlsx")
		 scope->ViewNameField->value = "xlsx")
		(("PDF (*.pdf)")
		 scope->FileNameField->value = strcat(buildString(reverse(cdr(reverse(parseString(scope->FileNameField->value ".")))) "") ".pdf")
		 scope->ViewNameField->value = "pdf")
		(("HTML (*.html)")
		 scope->FileNameField->value = strcat(buildString(reverse(cdr(reverse(parseString(scope->FileNameField->value ".")))) "") ".html")
		 scope->ViewNameField->value = "html")
   ) ; case
   nil
) ; procedure

list(nil
	'CombinedGUI CombinedGUI
))

putprop(Import['Softworks] NewDocViewGUI 'NewDocViewGUI)
)
; Must be *outside* the package let: assigning inside the let can leave SdmCombinedGUI
; scoped to the let, so SdmXLSX and boundp('SdmCombinedGUI) do not see it after load.
SdmCombinedGUI = Import['Softworks]->NewDocViewGUI->CombinedGUI
