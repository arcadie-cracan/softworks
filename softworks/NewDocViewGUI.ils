; Tracing: SOFTWORKS_GUI_TRACE=1, SOFTWORKS_TRIGGER_TRACE=1, SOFTWORKS_DEBUG=1,
; or SOFTWORKS_NEW_DOC_GUI_DEBUG=1 for Documentation Cell View stepping ([Softworks NDGUI] G*, V*).
; Fine DEBASE stepping inside GUICellView / Normalize: SOFTWORKS_GUICELLVIEW_DEBASE_STEP=1 (GVstepNN warns).
; DEBASE: when(or(...)) / when(member(...)) can see predicate symbol t → eval: not a function - t.
; Return only 1 or nil so when(SoftworksNewDocGuiVerboseP() ...) never expands to when(t ...).
procedure(SoftworksNewDocViewTraceP()
  cond(
    ((neq nil getShellEnvVar("SOFTWORKS_GUI_TRACE")) 1)
    ((neq nil getShellEnvVar("SOFTWORKS_TRIGGER_TRACE")) 1)
    ((neq nil getShellEnvVar("SOFTWORKS_DEBUG")) 1)
    ((equal 0 0) nil)))

; Documentation Cell View dialog: extra step logs without full GUI trace.
; SOFTWORKS_NEW_DOC_GUI_DEBUG=1 OR any SoftworksNewDocViewTraceP() env.
procedure(SoftworksNewDocGuiVerboseP()
  cond(
    ((neq nil SoftworksNewDocViewTraceP()) 1)
    ((neq nil getShellEnvVar("SOFTWORKS_NEW_DOC_GUI_DEBUG")) 1)
    ((equal 0 0) nil)))

; GVstepNN warns when verbose/trace OR SOFTWORKS_GUICELLVIEW_DEBASE_STEP is set (DEBASE-safe cond only).
procedure(SoftworksGUICellViewStepTraceP()
  cond(
    ((neq nil SoftworksNewDocGuiVerboseP()) 1)
    ((neq nil getShellEnvVar("SOFTWORKS_GUICELLVIEW_DEBASE_STEP")) 1)
    ((equal 0 0) nil)))

; Default path for ?defValue: same rules as SoftworksInvokeProjectDocDir (builtins only).
; DEBASE: path assignments must use prog1(setq(...) nil); caller sets defaultImportPath via
; prog2(setq(...) nil) — intermediate path strings must not surface as evaluated functor tails.
procedure(SoftworksNewDocViewFilePathDefault()
	let(((docEnv (getShellEnvVar("SOFTWORKS_DOC_DIR")))
	     (rootEnv (getShellEnvVar("SOFTWORKS_PROJECT_ROOT")))
	     (path nil))
	  progn(
	    when(SoftworksNewDocGuiVerboseP()
	      warn(
		"[Softworks GUI] defValue path: SoftworksInvokeProjectDocDir (env + pwd, builtins only)"))
	    nil)
	  cond(
	    ((neq docEnv nil)
	      cond(
	        ((neq strlen(docEnv) 0)
	          prog1(setq(path strcat(docEnv "/")) nil))
	        ((equal 0 0)
	          cond(
	            ((neq rootEnv nil)
	              cond(
	                ((neq strlen(rootEnv) 0)
	                  prog1(setq(path strcat(rootEnv "/doc/")) nil))
	                ((equal 0 0)
	                  progn(
	                    warn(sprintf(nil
			      "Softworks: SOFTWORKS_DOC_DIR and SOFTWORKS_PROJECT_ROOT are not set; using the default doc import path %s/doc/ (current working directory as project root)."
			      pwd()))
	                    prog1(setq(path strcat(pwd() "/doc/")) nil))))))
	            ((equal 0 0)
	              progn(
	                warn(sprintf(nil
			  "Softworks: SOFTWORKS_DOC_DIR and SOFTWORKS_PROJECT_ROOT are not set; using the default doc import path %s/doc/ (current working directory as project root)."
			  pwd()))
	                prog1(setq(path strcat(pwd() "/doc/")) nil))))))
	    ((neq rootEnv nil)
	      cond(
	        ((neq strlen(rootEnv) 0)
	          prog1(setq(path strcat(rootEnv "/doc/")) nil))
	        ((equal 0 0)
	          progn(
	            warn(sprintf(nil
		      "Softworks: SOFTWORKS_DOC_DIR and SOFTWORKS_PROJECT_ROOT are not set; using the default doc import path %s/doc/ (current working directory as project root)."
		      pwd()))
	            prog1(setq(path strcat(pwd() "/doc/")) nil)))))
	    ((equal 0 0)
	      progn(
	        warn(sprintf(nil
		  "Softworks: SOFTWORKS_DOC_DIR and SOFTWORKS_PROJECT_ROOT are not set; using the default doc import path %s/doc/ (current working directory as project root)."
		  pwd()))
	        prog1(setq(path strcat(pwd() "/doc/")) nil))))
	  path))

; DEBASE: blankstrp may be absent on stripped stacks → eval: not a function - nil.
procedure(SoftworksBlankStringp(s)
  cond(
    ((neq stringp(s) nil) eq(strlen(s) 0))
    ((equal 0 0) nil)))

; Map lib/cell/view name or DEBASE rootType / viewType tag to xlsx|pptx|pdf|html for doc GUI defaults.
procedure(SoftworksNormalizeDocKindTag(tagRaw)
	let(((tag ""))
	  cond(((neq SoftworksGUICellViewStepTraceP() nil)
	    warn(sprintf(nil "[Softworks NDGUI] GVnorm enter tagRaw=%L" tagRaw))))
	  tag = cond(
	    ((neq stringp(tagRaw) nil) tagRaw)
	    ((neq symbolp(tagRaw) nil) sprintf(nil "%s" tagRaw))
	    ((equal 0 0) ""))
	  ; DEBASE: if(... then ... else ...) expands to cond with (t else-expr); avoid if entirely.
	  cond(
	    ((neq tag "") cond(
	      ((neq member(tag '("xlsx" "pptx" "pdf" "html")) nil) tag)
	      ((neq member(tag '("pdf_view")) nil) "pdf")
	      ((equal 0 0) nil)))
	    ((equal 0 0) nil))))

let((NewDocViewGUI
	   (module_description "The Gui for creating and importing documentation views"))
NewDocViewGUI = let(((SoftworksNdDummy nil))

; Imports an existing documentation file. (PPTX, PDF, Excel)  Main callback for the form.
;procedure( importDocCB(o_field form g_item)
procedure( importDocCB( form )
let((LibName CellName ViewName FileName viewFileObj overwrite cpSuccess fileSourceDescription form)
	if( form == nil then
		form = hiGetCurrentForm()
	) ; if
	LibName  = form->LibNameField->value
	CellName = form->CellNameField->value
	ViewName = form->ViewNameField->value
	FileName = form->FileNameField->value

	if(!CheckExtension(FileName)
		error("The file %s does not have a supported file extension" FileName)
	)
	if( form->ImportNewDropdown->value == "Import" then
		viewFileObj = ddGetObj(LibName CellName ViewName nil nil "r")
		if( viewFileObj then
			overwrite = hiDisplayAppDBox(
				?name 'OverwriteDBox
				?dboxBanner "Overwrite Existing Cellview?"
				?dboxText strcat("Do you want to overwrite the following existing cell view?\nLib: " LibName "\nCell: " CellName "\nView: " ViewName)
				)
			when(overwrite && ddNeedCheckout(viewFileObj)
				ddCheckout(viewFileObj))
		else
			overwrite = t ;Cell doesn't exist yet
		) ;if
		when(overwrite
		;Create the view
			viewFileObj=ddGetObj(LibName CellName ViewName FileName nil "w")
			cpSuccess = fileSourceDescription = sprintf(nil "Imported from %s" form->FilePathField->value)
			shell(strcat("cp -f " EscapeSpecialCharacters(form->FilePathField->value) " " viewFileObj~>writePath)) ; Import the selected file
			if(not(cpSuccess) then
				error("The file copy failed.  Could not copy from %s to %s" EscapeSpecialCharacters(form->FilePathField->value) viewFileObj~>writePath)
			else
				printf("Created %s %s %s cell view %s" LibName CellName ViewName fileSourceDescription)
			) ; if
		) ;when
	else
		viewFileObj=ddGetObj(LibName CellName ViewName FileName nil "w")
		cpSuccess = fileSourceDescription = sprintf(nil "New cell created from %s" form->FilePathField->value)
		case(form->ContentsOption->value
			(("Power Point (*.pptx)")
				;shell(strcat("cp -f " getShellEnvVar("SkyVerTemplatePath") "DesignTemplate.pptx " viewFileObj~>writePath))) ; Copy blank skyworks template presentation
				; system(sprintf(nil "cp $SOFTWORKS_ROOT/src/skill/%s %s" templateName file))
				shell(strcat("cp -f " EscapeSpecialCharacters(softworksBlankDocTemplatePath("pptx/pptxTemplate.pptx")) " " viewFileObj~>writePath)))
			(("Excel Spreadsheet (*.xlsx)")
				shell(strcat("cp -f " EscapeSpecialCharacters(softworksBlankDocTemplatePath("xlsx/xlsxTemplate.xlsx")) " " viewFileObj~>writePath)))
			(("PDF (*.pdf)")
				shell(strcat("cp -f " EscapeSpecialCharacters(softworksBlankDocTemplatePath("pdf/pdfTemplate.pdf")) " " viewFileObj~>writePath)))
			(("HTML (*.html)")
				shell(strcat("cp -f " EscapeSpecialCharacters(softworksBlankDocTemplatePath("html/htmlTemplate.html")) " " viewFileObj~>writePath)))
		)
		if(not(cpSuccess) then
			error("The file copy failed.  Could not copy from %s to %s" EscapeSpecialCharacters(form->FilePathField->value) viewFileObj~>writePath)
		else
			printf("Created %s %s %s cell view %s" LibName CellName ViewName fileSourceDescription)
		)
	) ; if statement for import / new cell view
	ddUpdateLibList() ; Update library list
	hiSetCallbackStatus(form t)
	hiFormUnmap(form)
)
)

; Choose between import or new cell
procedure( CombinedGUI(LibSelected CellSelected ViewSelected @optional RootTypeHint)
let((SelectionL newForm formName)
	progn(
	  when(SoftworksNewDocGuiVerboseP()
	    warn(sprintf(nil
	      "[Softworks NDGUI] CombinedGUI G0 enter lib=%L cell=%L view=%L rootTypeHint=%L"
	      LibSelected CellSelected ViewSelected RootTypeHint)))
	  nil)
	progn(
	  when(SoftworksNewDocGuiVerboseP()
	    warn("[Softworks NDGUI] CombinedGUI G0b calling GUICellView"))
	  nil)
	SelectionL = GUICellView(LibSelected CellSelected ViewSelected RootTypeHint)
	progn(
	  when(SoftworksNewDocGuiVerboseP()
	    warn(sprintf(nil
	      "[Softworks NDGUI] CombinedGUI G1 GUICellView returned fieldsCar=%L selectionTail=%L"
	      car(SelectionL)
	      cdr(SelectionL))))
	  nil)
	formName = gensym('importGUIDocForm)
	progn(
	  when(SoftworksNewDocGuiVerboseP()
	    warn(sprintf(nil "[Softworks NDGUI] CombinedGUI G2 gensym formName=%L" formName)))
	  nil)
	progn(
	  when(SoftworksNewDocGuiVerboseP()
	    warn(sprintf(nil "[Softworks NDGUI] CombinedGUI G3 hiCreateAppForm fieldsCar=%L"
	      car(SelectionL))))
	  nil)
	newForm = hiCreateAppForm(
		?name formName
		?formTitle "Documentation Cell View"
		?fields car(SelectionL)
		?buttonLayout 'OKCancelApply
		?callback	importDocCB
;		?formType 'nonOptions
		?unmapAfterCB t
	)
	progn(
	  when(SoftworksNewDocGuiVerboseP()
	    warn(sprintf(nil "[Softworks NDGUI] CombinedGUI G4 hiCreateAppForm -> newForm=%L" newForm)))
	  nil)
	putprop(formName "skyOpenSkyVerHelp()" 'hiHelpAction)
	progn(
	  when(SoftworksNewDocGuiVerboseP()
	    warn(sprintf(nil "[Softworks NDGUI] CombinedGUI G5 hiInstantiateForm(%L)" newForm)))
	  nil)
	hiInstantiateForm(newForm)
	progn(
	  when(SoftworksNewDocGuiVerboseP()
	    warn("[Softworks NDGUI] CombinedGUI G6 hiInstantiateForm returned"))
	  nil)
	progn(
	  when(SoftworksNewDocGuiVerboseP()
	    warn("[Softworks NDGUI] CombinedGUI G7 ddHiLinkFields Lib Cell View combos"))
	  nil)
	ddHiLinkFields(
		newForm->LibNameField
		newForm->CellNameField
		newForm->ViewNameField
	)
	progn(
	  when(SoftworksNewDocGuiVerboseP()
	    warn("[Softworks NDGUI] CombinedGUI G8 ddHiLinkFields returned"))
	  nil)
	progn(
	  when(SoftworksNewDocGuiVerboseP()
	    warn(sprintf(nil "[Softworks NDGUI] CombinedGUI G9 hiDisplayForm(%L)" newForm)))
	  nil)
	hiDisplayForm( newForm )
	progn(
	  when(SoftworksNewDocGuiVerboseP()
	    warn("[Softworks NDGUI] CombinedGUI G10 hiDisplayForm returned"))
	  nil)
	nil
))

; Create basic GUI with button for import or new view
procedure( GUICellView(LibSelected CellSelected ViewSelected @optional RootTypeHint)
  let((SelectionL defaultImportPath viewTag viewDocKind docKind unknownDocKind importNewDef contentsDef
	filePathInvisible contentsInvisible fileNameDef)
	cond(((neq SoftworksGUICellViewStepTraceP() nil)
	  warn(sprintf(nil "[Softworks NDGUI] GVstep00 enter Lib=%L Cell=%L View=%L RootHint=%L"
	    LibSelected CellSelected ViewSelected RootTypeHint))))
	; tconc(nil ...) is required; if SelectionL were ever resolved as global (e.g. symbol t), DEBASE hits eval: not a function - t.
	SelectionL = nil
	cond(((neq SoftworksGUICellViewStepTraceP() nil) warn("[Softworks NDGUI] GVstep01 SelectionL=nil")))
	viewTag = cond(
	  ((neq stringp(ViewSelected) nil) ViewSelected)
	  ((neq symbolp(ViewSelected) nil) sprintf(nil "%s" ViewSelected))
	  ((equal 0 0) ""))
	cond(((neq SoftworksGUICellViewStepTraceP() nil)
	  warn(sprintf(nil "[Softworks NDGUI] GVstep02 viewTag=%L" viewTag))))
	viewDocKind = SoftworksNormalizeDocKindTag(viewTag)
	cond(((neq SoftworksGUICellViewStepTraceP() nil)
	  warn(sprintf(nil "[Softworks NDGUI] GVstep03 viewDocKind=%L" viewDocKind))))
	; DEBASE: or(...) lowers to cond ((t second)); never use or here.
	docKind = cond(
	  ((neq viewDocKind nil) viewDocKind)
	  ((equal 0 0) SoftworksNormalizeDocKindTag(RootTypeHint)))
	cond(((neq SoftworksGUICellViewStepTraceP() nil)
	  warn(sprintf(nil "[Softworks NDGUI] GVstep04 docKind=%L" docKind))))
	; DEBASE treats cond/when clauses like (t ...) or when(t ...) as (apply t ...): never use symbol t as flag/predicate CAR.
	unknownDocKind = nil
	; DEBASE: unless(nil ...) expands like when(t ...) / cond (t ...) — never use unless here.
	cond(
	  ((eq docKind nil) unknownDocKind = 'SoftworksUnknownDocKind)
	  ((neq SoftworksBlankStringp(docKind) nil) unknownDocKind = 'SoftworksUnknownDocKind))
	cond(((neq SoftworksGUICellViewStepTraceP() nil)
	  warn(sprintf(nil "[Softworks NDGUI] GVstep05 unknownDocKind=%L" unknownDocKind))))
	importNewDef = "Import"
	cond(
	  ((eq unknownDocKind nil) importNewDef = "New"))
	cond(((neq SoftworksGUICellViewStepTraceP() nil)
	  warn(sprintf(nil "[Softworks NDGUI] GVstep06 importNewDef=%L" importNewDef))))
	contentsDef = cond(
	  ((neq unknownDocKind nil) "Power Point (*.pptx)")
	  ((neq member(docKind '("xlsx")) nil) "Excel Spreadsheet (*.xlsx)")
	  ((neq member(docKind '("pptx")) nil) "Power Point (*.pptx)")
	  ((neq member(docKind '("pdf")) nil) "PDF (*.pdf)")
	  ((neq member(docKind '("html")) nil) "HTML (*.html)")
	  ((equal 0 0) "Power Point (*.pptx)"))
	cond(((neq SoftworksGUICellViewStepTraceP() nil)
	  warn(sprintf(nil "[Softworks NDGUI] GVstep07 contentsDef=%L" contentsDef))))
	filePathInvisible = nil
	cond(
	  ((eq unknownDocKind nil) filePathInvisible = t))
	cond(((neq SoftworksGUICellViewStepTraceP() nil)
	  warn(sprintf(nil "[Softworks NDGUI] GVstep08 filePathInvisible=%L" filePathInvisible))))
	contentsInvisible = nil
	cond(
	  ((neq unknownDocKind nil) contentsInvisible = t))
	cond(((neq SoftworksGUICellViewStepTraceP() nil)
	  warn(sprintf(nil "[Softworks NDGUI] GVstep09 contentsInvisible=%L" contentsInvisible))))
	fileNameDef = cond(
	  ((neq unknownDocKind nil) "Review.pptx")
	  ((neq member(docKind '("xlsx")) nil)
	    cond(
	      ((neq member(viewTag '("xlsx")) nil) "Review.xlsx")
	      ((equal 0 0) sprintf(nil "%s.xlsx" viewTag))))
	  ((neq member(docKind '("pptx")) nil)
	    cond(
	      ((neq member(viewTag '("pptx")) nil) "Review.pptx")
	      ((equal 0 0) sprintf(nil "%s.pptx" viewTag))))
	  ((neq member(docKind '("pdf")) nil)
	    cond(
	      ((neq member(viewTag '("pdf")) nil) "Review.pdf")
	      ((neq member(viewTag '("pdf_view")) nil) "Review.pdf")
	      ((equal 0 0) sprintf(nil "%s.pdf" viewTag))))
	  ((neq member(docKind '("html")) nil)
	    cond(
	      ((neq member(viewTag '("html")) nil) "Review.html")
	      ((equal 0 0) sprintf(nil "%s.html" viewTag))))
	  ((equal 0 0) "Review.pptx"))
	cond(((neq SoftworksGUICellViewStepTraceP() nil)
	  warn(sprintf(nil "[Softworks NDGUI] GVstep10 fileNameDef=%L" fileNameDef))))
	cond(((neq SoftworksGUICellViewStepTraceP() nil) warn("[Softworks NDGUI] GVstep11 before V1 progn")))
	progn(
	  when(SoftworksNewDocGuiVerboseP()
	    warn(sprintf(nil
	      "[Softworks GUI] GUICellView V1 enter lib=%L cell=%L view=%L rootHint=%L viewTag=%L docKind=%L unknownDocKind=%L importNewDef=%L fileNameDef=%L pathInvisible=%L typeInvisible=%L"
	      LibSelected CellSelected ViewSelected RootTypeHint viewTag docKind unknownDocKind importNewDef fileNameDef filePathInvisible contentsInvisible)))
	  nil)
	cond(((neq SoftworksGUICellViewStepTraceP() nil) warn("[Softworks NDGUI] GVstep12 before SoftworksNewDocViewFilePathDefault")))
	prog2(setq(defaultImportPath SoftworksNewDocViewFilePathDefault()) nil)
	cond(((neq SoftworksGUICellViewStepTraceP() nil)
	  warn(sprintf(nil "[Softworks NDGUI] GVstep13 defaultImportPath=%L" defaultImportPath))))
	; LIB, CELL, VIEW SELECTION
	SelectionL = tconc(SelectionL list(ddHiCreateLibraryComboField(
		?name       'LibNameField
		?prompt     "Library"
		?defValue    LibSelected
		?toolTip	"Library Name"
		?validationType	 'allowExisting
	    ?editable  t)
		5:10 400:30 60))
	progn(
	  when(SoftworksNewDocGuiVerboseP()
	    warn("[Softworks NDGUI] GUICellView V2 after ddHiCreateLibraryComboField"))
	  nil)
	SelectionL = tconc(SelectionL list(ddHiCreateCellComboField(
		?name      'CellNameField
	    ?prompt    "Cell"
	    ?defValue   CellSelected
		?toolTip	"Cell Name"
		?validationType	 'allowAny
	    ?editable    t)
		5:50 400:30 60))
	SelectionL = tconc(SelectionL list(ddHiCreateViewComboField(
		?name      'ViewNameField
	    ?prompt    "View"
	    ?defValue  ViewSelected
		?toolTip	   "View Name"
		?validationType	 'allowAny
	    ?editable   t)
		5:90 400:30 60))
	progn(
	  when(SoftworksNewDocGuiVerboseP()
	    warn("[Softworks NDGUI] GUICellView V3 after view combo, before ImportNewDropdown cyclic"))
	  nil)
	SelectionL = tconc(SelectionL list(hiCreateCyclicField(
		?name      'ImportNewDropdown
		?choices   '("Import" "New")
		?defValue  importNewDef
		?prompt    "Type of Cell:"
		?callback   changeViewToImport
		?keepHistory t)
		5:130 400:30 90))
	progn(
	  when(SoftworksNewDocGuiVerboseP()
	    warn("[Softworks NDGUI] GUICellView V4 ImportNewDropdown cyclic field created"))
	  nil)
	progn(
	  when(SoftworksNewDocGuiVerboseP()
	    warn("[Softworks NDGUI] GUICellView V5 before FilePathField"))
	  nil)
	; Import Cell View (Default). No ?modifyCallback: DEBASE can apply the callback return as a
	; function (errors like not a function - t or - "/path/"). Set file name in FileNameField.
	SelectionL = tconc(SelectionL list(hiCreateFileSelectorField(
		?name     'FilePathField
		?mode     'existingFile
		?prompt   "Import File Path"
		?defValue  defaultImportPath
		?invisible filePathInvisible
		?editable  t)
		5:170 400:30 100))
	progn(
	  when(SoftworksNewDocGuiVerboseP()
	    warn("[Softworks NDGUI] GUICellView V6 FilePathField created"))
	  nil)
	SelectionL = tconc(SelectionL list(hiCreateStringField(
		?name      'FileNameField
	  ?prompt    "File Name"
	  ?defValue  fileNameDef
		?modifyCallback CheckFileName
	  ?editable  t
		?enabled   t)
		5:210 400:30 100))

	progn(
	  when(SoftworksNewDocGuiVerboseP()
	    warn("[Softworks NDGUI] GUICellView V7 FileNameField created"))
	  nil)

	; New Cell View
	SelectionL = tconc(SelectionL list(hiCreateCyclicField(
		?name       'ContentsOption
		?choices    '("Power Point (*.pptx)" "Excel Spreadsheet (*.xlsx)" "PDF (*.pdf)" "HTML (*.html)")
		?defValue   contentsDef
		?callback   UpdateFileContents
		?prompt     "File Type"
		?invisible  contentsInvisible
		?enabled   t
		?keepHistory t)
		5:170 400:30 100))
	progn(
	  when(SoftworksNewDocGuiVerboseP()
	    warn("[Softworks NDGUI] GUICellView V8 ContentsOption cyclic created"))
	  nil)
	progn(
	  when(SoftworksNewDocGuiVerboseP()
	    warn("[Softworks NDGUI] GUICellView V9 returning SelectionL -> CombinedGUI"))
	  nil)
	SelectionL
))

; Adjust GUI options for either New cell or Import cell formats
; DEBASE may pass symbol New or string "New"; treat both as New. HI cyclic callbacks must return nil.
procedure( changeViewToImport( o_field g_scope g_item )
	progn(
	  when(SoftworksNewDocGuiVerboseP()
	    warn(sprintf(nil "[Softworks NDGUI] changeViewToImport enter g_item=%L stringp=%L symbolp=%L"
	      g_item stringp(g_item) symbolp(g_item))))
	  nil)
	cond(
	  ((and g_scope g_scope->FilePathField g_scope->ContentsOption)
	   let(((pickNew nil))
	     pickNew = cond(
	       ((neq member(g_item list("New" 'New)) nil) 1)
	       ((neq (stringp(g_item) && zerop(strcmp(g_item "New"))) nil) 1)
	       ((neq (symbolp(g_item) && zerop(strcmp(sprintf(nil "%s" g_item) "New"))) nil) 1)
	       ((equal 0 0) nil))
	     cond(
	       ((eq pickNew nil)
		 progn(
		   g_scope->ContentsOption->invisible = t
		   g_scope->FilePathField->invisible = nil))
	       ((equal 0 0)
		 progn(
		   g_scope->FilePathField->invisible = t
		   g_scope->ContentsOption->invisible = nil)))
	     nil)))
)

; Update the file name to work nicely with Unix
procedure( CheckFileName(_field _scope t_latestTextValue _g_sourceOfChange)
let( (comPat1 comPat2 comPat3 out)
	; replaces spaces with underscores
	comPat1 = pcreCompile( " " )
	out = pcreReplace( comPat1 t_latestTextValue "_" 0 )
	; Keeps the user from entering the following special characters: * / > < : [ ] | ( ) ; # @ ! $ ^ -
	;comPat2 = pcreCompile( "[\\*/><:&\\[\\]\\|();#@!\\$%\\^\\-]" )
	;pcreReplace( comPat2 out "" 0 )
	; Only allow alphanumeric characters, "."" and "_"
	comPat2 = pcreCompile( "[^A-Z^a-z^0-9^_^\\.]+" )
	out = pcreReplace( comPat2 out "" 0 )
  comPat3 = pcreCompile( "[\\^]" )
	out = pcreReplace( comPat3 out "" 0 )
  out
))

procedure( CheckExtension(file)
	strcmp(substring(file -5) ".pptx") ||
	strcmp(substring(file -4) ".pdf") ||
	strcmp(substring(file -5) ".xlsx") ||
	strcmp(substring(file -5) ".xlsm") ||
	strcmp(substring(file -4) ".mdf") ||
	strcmp(substring(file -4) ".txt") ||
	strcmp(substring(file -4) ".hml") ||
	strcmp(substring(file -5) ".html")
)

procedure( EscapeSpecialCharacters(t_fileName)
let( (comPat1 comPat2 comPat3 out)
	; escape spaces
	comPat1 = pcreCompile( " " )
	out = pcreReplace( comPat1 t_fileName "\\\\ " 0 )
	; escape &
	comPat2 = pcreCompile( "\\&" )
	out = pcreReplace( comPat2 out "\\& " 0 )
	; escape *
	comPat3 = pcreCompile( "\\*" )
	out = pcreReplace( comPat3 out "\\* " 0 )
))

; HI treats cyclic ?callback return as callable — progn forces nil result (case yields t from assigns).
procedure( UpdateFileContents(_field scope item)
	progn(
	  case(item
		(("Power Point (*.pptx)")
		 scope->FileNameField->value = strcat(buildString(reverse(cdr(reverse(parseString(scope->FileNameField->value ".")))) "") ".pptx")
		 scope->ViewNameField->value = "pptx")
		(("Excel Spreadsheet (*.xlsx)")
		 scope->FileNameField->value = strcat(buildString(reverse(cdr(reverse(parseString(scope->FileNameField->value ".")))) "") ".xlsx")
		 scope->ViewNameField->value = "xlsx")
		(("PDF (*.pdf)")
		 scope->FileNameField->value = strcat(buildString(reverse(cdr(reverse(parseString(scope->FileNameField->value ".")))) "") ".pdf")
		 scope->ViewNameField->value = "pdf")
		(("HTML (*.html)")
		 scope->FileNameField->value = strcat(buildString(reverse(cdr(reverse(parseString(scope->FileNameField->value ".")))) "") ".html")
		 scope->ViewNameField->value = "html")
	  ) ; case
	  nil))

list(nil
	'CombinedGUI CombinedGUI
))

putprop(Import['Softworks] NewDocViewGUI 'NewDocViewGUI)
)
; Must be *outside* the package let: assigning inside the let can leave SdmCombinedGUI
; scoped to the let, so SdmXLSX and boundp('SdmCombinedGUI) do not see it after load.
SdmCombinedGUI = Import['Softworks]->NewDocViewGUI->CombinedGUI
