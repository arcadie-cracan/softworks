; Default path helper: delegates to SoftworksDocPathFillFromEnv (Softworks.ils).
; DEBASE GUICellView uses SoftworksDocImportPathResult + ?defValue — no prog2(local setq).
procedure(SoftworksNewDocViewFilePathDefault()
  SoftworksDocPathFillFromEnv()
  SoftworksDocImportPathResult)

; DEBASE: blankstrp may be absent on stripped stacks → eval: not a function - nil.
procedure(SoftworksBlankStringp(s)
  cond(
    ((neq stringp(s) nil) eq(strlen(s) 0))
    ((equal 0 0) nil)))

; Map lib/cell/view name or DEBASE rootType / viewType tag to xlsx|pptx|pdf|html|docx for doc GUI defaults.
procedure(SoftworksNormalizeDocKindTag(tagRaw)
	let(((tag ""))
	  tag = cond(
	    ((neq stringp(tagRaw) nil) tagRaw)
	    ((neq symbolp(tagRaw) nil) sprintf(nil "%s" tagRaw))
	    ((equal 0 0) ""))
	  cond(
	    ((neq tag "") cond(
	      ((neq member(tag '("xlsx" "pptx" "pdf" "html" "docx")) nil) tag)
	      ((neq member(tag '("pdf_view")) nil) "pdf")
	      ((equal 0 0) nil)))
	    ((equal 0 0) nil))))

let((NewDocViewGUI
	   (module_description "The Gui for creating and importing documentation views"))
NewDocViewGUI = let(((SoftworksNdDummy nil))

; Shared: launch the external editor for a newly created/imported view.
procedure( launchDocEditor(fp ext)
  cond(
    ((equal ext "xlsx")
     let(((m VrtImport['Softworks]->XLSX))
       cond(((neq procedurep(m->startReader) nil) m->startReader(fp)))))
    ((equal ext "pptx")
     let(((m VrtImport['Softworks]->PPTX))
       cond(((neq procedurep(m->startReader) nil) m->startReader(fp)))))
    ((equal ext "pdf")
     let(((m VrtImport['Softworks]->PDF))
       cond(((neq procedurep(m->startReader) nil) m->startReader(fp)))))
    ((equal ext "html")
     ipcBeginProcess(strcat("firefox " fp) "" nil nil))
    ((equal ext "docx")
     let(((m VrtImport['Softworks]->DOCX))
       cond(((neq procedurep(m->startReader) nil) m->startReader(fp)))))))

; Callback for the New Documentation Cell View form (DataTrigger path).
; Creates a blank cell view from a template and launches the editor.
procedure( createViewCB( form )
let((LibName CellName ViewName FileName viewFileObj cpSuccess)
	if( form == nil then
		form = hiGetCurrentForm()
	)
	LibName  = form->LibNameField->value
	CellName = form->CellNameField->value
	ViewName = form->ViewNameField->value
	FileName = form->FileNameField->value

	if(!CheckExtension(FileName)
		error("The file %s does not have a supported file extension" FileName)
	)
	viewFileObj = ddGetObj(LibName CellName ViewName FileName nil "w")
	if(viewFileObj == nil then
		error("Cannot create cell view %s %s %s with file name %s" LibName CellName ViewName FileName)
	)
	let(((templatePath nil) (writePath viewFileObj~>writePath))
	  case(form->ContentsOption->value
		(("Power Point (*.pptx)")
			templatePath = softworksBlankDocTemplatePath("pptx/pptxTemplate.pptx"))
		(("Excel Spreadsheet (*.xlsx)")
			templatePath = softworksBlankDocTemplatePath("xlsx/xlsxTemplate.xlsx"))
		(("PDF (*.pdf)")
			templatePath = softworksBlankDocTemplatePath("pdf/pdfTemplate.pdf"))
		(("HTML (*.html)")
			templatePath = softworksBlankDocTemplatePath("html/htmlTemplate.html"))
		(("Word Document (*.docx)")
			templatePath = softworksBlankDocTemplatePath("docx/docxTemplate.docx"))
	  )
	  let(((sourcePath templatePath))
	    cond(
		  ((neq isReadable(templatePath) t)
		   warn("Softworks: template %s not found; falling back to built-in template." templatePath)
		   sourcePath = strcat(SoftworksInstallDir "/templates/" car(reverse(parseString(templatePath "/"))))))
	    cpSuccess = shell(strcat("cp -f " EscapeSpecialCharacters(sourcePath) " " EscapeSpecialCharacters(writePath)))
	    if(not(cpSuccess) then
		  error("The file copy failed.  Could not copy template %s to %s" sourcePath writePath)
	    else
		  printf("Created %s %s %s cell view from template %s\n" LibName CellName ViewName sourcePath)
	    )
	  )
	)
	ddUpdateLibList()
	hiSetCallbackStatus(form t)
	hiFormUnmap(form)
	cond(
	  ((neq cpSuccess nil)
	   launchDocEditor(viewFileObj~>writePath car(reverse(parseString(FileName "."))))))
))

; Callback for the Import Document as Cell View form (Library Manager path).
; Copies an existing file as the master of a new (or overwritten) cell view.
procedure( createViewFromFileCB( form )
let((LibName CellName ViewName FileName FilePath viewFileObj overwrite cpSuccess)
	if( form == nil then
		form = hiGetCurrentForm()
	)
	LibName  = form->LibNameField->value
	CellName = form->CellNameField->value
	ViewName = form->ViewNameField->value
	FilePath = form->FilePathField->value
	FileName = form->FileNameField->value
	; Default file name to the source file's basename when left blank.
	cond(
	  ((neq SoftworksBlankStringp(FileName) nil)
	   FileName = car(reverse(parseString(FilePath "/")))))
	if(!CheckExtension(FileName)
		error("The file %s does not have a supported file extension" FileName)
	)
	viewFileObj = ddGetObj(LibName CellName ViewName nil nil "r")
	if( viewFileObj then
		overwrite = hiDisplayAppDBox(
			?name 'OverwriteDBox
			?dboxBanner "Overwrite Existing Cell View?"
			?dboxText strcat("Do you want to overwrite the following existing cell view?\nLib: " LibName "\nCell: " CellName "\nView: " ViewName)
			)
		when(overwrite && ddNeedCheckout(viewFileObj)
			ddCheckout(viewFileObj))
	else
		overwrite = t
	)
	when(overwrite
		viewFileObj = ddGetObj(LibName CellName ViewName FileName nil "w")
		cpSuccess = shell(strcat("cp -f " EscapeSpecialCharacters(FilePath) " " viewFileObj~>writePath))
		if(not(cpSuccess) then
			error("The file copy failed.  Could not copy %s to %s" EscapeSpecialCharacters(FilePath) viewFileObj~>writePath)
		else
			printf("Imported %s as %s %s %s cell view\n" FilePath LibName CellName ViewName)
		)
	)
	ddUpdateLibList()
	hiSetCallbackStatus(form t)
	hiFormUnmap(form)
	cond(
	  ((neq cpSuccess nil)
	   launchDocEditor(viewFileObj~>writePath car(reverse(parseString(FileName "."))))))
))

; DataTrigger path: open when view doesn't exist — New cell view only.
procedure( CombinedGUI(LibSelected CellSelected ViewSelected @optional RootTypeHint)
let((SelectionL newForm formName)
	SoftworksDocPathFillFromEnv()
	SelectionL = GUICellView(LibSelected CellSelected ViewSelected RootTypeHint)
	formName = gensym('newDocViewForm)
	newForm = hiCreateAppForm(
		?name formName
		?formTitle "New Documentation Cell View"
		?fields car(SelectionL)
		?buttonLayout 'OKCancelApply
		?callback createViewCB
		?unmapAfterCB t
	)
	hiInstantiateForm(newForm)
	; Link only Lib→Cell; ViewNameField is free-text (allowAny) and must keep ViewSelected.
	ddHiLinkFields(
		newForm->LibNameField
		newForm->CellNameField
	)
	hiDisplayForm( newForm )
	nil
))

; Library Manager path: import an existing file as a cell view master.
procedure( CreateViewFromFileGUI(@optional (LibSelected "") (CellSelected "") (ViewSelected ""))
let((SelectionL newForm formName)
	SoftworksDocPathFillFromEnv()
	SelectionL = nil
	SelectionL = tconc(SelectionL list(ddHiCreateLibraryComboField(
		?name       'LibNameField
		?prompt     "Library"
		?defValue    LibSelected
		?toolTip    "Library Name"
		?validationType  'allowExisting
		?editable  t)
		5:10 400:30 60))
	SelectionL = tconc(SelectionL list(ddHiCreateCellComboField(
		?name      'CellNameField
		?prompt    "Cell"
		?defValue   CellSelected
		?toolTip    "Cell Name"
		?validationType  'allowAny
		?editable    t)
		5:50 400:30 60))
	SelectionL = tconc(SelectionL list(ddHiCreateViewComboField(
		?name      'ViewNameField
		?prompt    "View"
		?defValue  ViewSelected
		?toolTip       "View Name"
		?validationType  'allowAny
		?editable   t)
		5:90 400:30 60))
	SelectionL = tconc(SelectionL list(hiCreateFileSelectorField(
		?name     'FilePathField
		?mode     'existingFile
		?prompt   "Source File"
		?defValue  SoftworksDocImportPathResult
		?editable  t)
		5:130 400:30 100))
	SelectionL = tconc(SelectionL list(hiCreateStringField(
		?name      'FileNameField
		?prompt    "Import as File Name"
		?defValue  ""
		?toolTip   "Leave Blank to Use Source File Name"
		?modifyCallback CheckFileName
		?editable  t
		?enabled   t)
		5:170 400:30 100))
	formName = gensym('importFileDocForm)
	newForm = hiCreateAppForm(
		?name formName
		?formTitle "Import Document as Cell View"
		?fields car(SelectionL)
		?buttonLayout 'OKCancelApply
		?callback createViewFromFileCB
		?unmapAfterCB t
	)
	hiInstantiateForm(newForm)
	ddHiLinkFields(
		newForm->LibNameField
		newForm->CellNameField
	)
	newForm->ViewNameField->value = ViewSelected
	hiDisplayForm( newForm )
	nil
))

; Build the New-view form fields (used by CombinedGUI).
procedure( GUICellView(LibSelected CellSelected ViewSelected @optional RootTypeHint)
  let((SelectionL viewTag viewDocKind docKind unknownDocKind contentsDef fileNameDef)
	SelectionL = nil
	viewTag = cond(
	  ((neq stringp(ViewSelected) nil) ViewSelected)
	  ((neq symbolp(ViewSelected) nil) sprintf(nil "%s" ViewSelected))
	  ((equal 0 0) ""))
	viewDocKind = SoftworksNormalizeDocKindTag(viewTag)
	docKind = cond(
	  ((neq viewDocKind nil) viewDocKind)
	  ((equal 0 0) SoftworksNormalizeDocKindTag(RootTypeHint)))
	unknownDocKind = nil
	cond(
	  ((eq docKind nil) unknownDocKind = 'SoftworksUnknownDocKind)
	  ((neq SoftworksBlankStringp(docKind) nil) unknownDocKind = 'SoftworksUnknownDocKind))
	contentsDef = cond(
	  ((neq unknownDocKind nil) "Power Point (*.pptx)")
	  ((neq member(docKind '("xlsx")) nil) "Excel Spreadsheet (*.xlsx)")
	  ((neq member(docKind '("pptx")) nil) "Power Point (*.pptx)")
	  ((neq member(docKind '("pdf")) nil) "PDF (*.pdf)")
	  ((neq member(docKind '("html")) nil) "HTML (*.html)")
	  ((neq member(docKind '("docx")) nil) "Word Document (*.docx)")
	  ((equal 0 0) "Power Point (*.pptx)"))
	fileNameDef = cond(
	  ((neq unknownDocKind nil) "Review.pptx")
	  ((neq member(docKind '("xlsx")) nil)
	    cond(
	      ((neq member(viewTag '("xlsx")) nil) "Review.xlsx")
	      ((equal 0 0) sprintf(nil "%s.xlsx" viewTag))))
	  ((neq member(docKind '("pptx")) nil)
	    cond(
	      ((neq member(viewTag '("pptx")) nil) "Review.pptx")
	      ((equal 0 0) sprintf(nil "%s.pptx" viewTag))))
	  ((neq member(docKind '("pdf")) nil)
	    cond(
	      ((neq member(viewTag '("pdf")) nil) "Review.pdf")
	      ((neq member(viewTag '("pdf_view")) nil) "Review.pdf")
	      ((equal 0 0) sprintf(nil "%s.pdf" viewTag))))
	  ((neq member(docKind '("html")) nil)
	    cond(
	      ((neq member(viewTag '("html")) nil) "Review.html")
	      ((equal 0 0) sprintf(nil "%s.html" viewTag))))
	  ((neq member(docKind '("docx")) nil)
	    cond(
	      ((neq member(viewTag '("docx")) nil) "Review.docx")
	      ((equal 0 0) sprintf(nil "%s.docx" viewTag))))
	  ((equal 0 0) "Review.pptx"))
	; LIB, CELL, VIEW SELECTION
	SelectionL = tconc(SelectionL list(ddHiCreateLibraryComboField(
		?name       'LibNameField
		?prompt     "Library"
		?defValue    LibSelected
		?toolTip    "Library Name"
		?validationType  'allowExisting
		?editable  t)
		5:10 400:30 60))
	SelectionL = tconc(SelectionL list(ddHiCreateCellComboField(
		?name      'CellNameField
		?prompt    "Cell"
		?defValue   CellSelected
		?toolTip    "Cell Name"
		?validationType  'allowAny
		?editable    t)
		5:50 400:30 60))
	SelectionL = tconc(SelectionL list(ddHiCreateViewComboField(
		?name      'ViewNameField
		?prompt    "View"
		?defValue  ViewSelected
		?toolTip       "View Name"
		?validationType  'allowAny
		?editable   t)
		5:90 400:30 60))
	SelectionL = tconc(SelectionL list(hiCreateStringField(
		?name      'FileNameField
		?prompt    "File Name"
		?defValue  fileNameDef
		?modifyCallback CheckFileName
		?editable  t
		?enabled   t)
		5:130 400:30 100))
	SelectionL = tconc(SelectionL list(hiCreateCyclicField(
		?name       'ContentsOption
		?choices    '("Power Point (*.pptx)" "Excel Spreadsheet (*.xlsx)" "PDF (*.pdf)" "HTML (*.html)" "Word Document (*.docx)")
		?defValue   contentsDef
		?callback   UpdateFileContents
		?prompt     "File Type"
		?enabled   t
		?keepHistory t)
		5:170 400:30 100))
	SelectionL
))

; Update the file name to work nicely with Unix
procedure( CheckFileName(_field _scope t_latestTextValue _g_sourceOfChange)
let( (comPat1 comPat2 comPat3 out)
	comPat1 = pcreCompile( " " )
	out = pcreReplace( comPat1 t_latestTextValue "_" 0 )
	comPat2 = pcreCompile( "[^A-Z^a-z^0-9^_^\\.]+" )
	out = pcreReplace( comPat2 out "" 0 )
	comPat3 = pcreCompile( "[\\^]" )
	out = pcreReplace( comPat3 out "" 0 )
	out
))

procedure( CheckExtension(file)
	strcmp(substring(file -5) ".pptx") ||
	strcmp(substring(file -4) ".pdf") ||
	strcmp(substring(file -5) ".xlsx") ||
	strcmp(substring(file -5) ".xlsm") ||
	strcmp(substring(file -4) ".mdf") ||
	strcmp(substring(file -4) ".txt") ||
	strcmp(substring(file -4) ".hml") ||
	strcmp(substring(file -5) ".html") ||
	strcmp(substring(file -5) ".docx")
)

procedure( EscapeSpecialCharacters(t_fileName)
let( (comPat1 comPat2 comPat3 out)
	comPat1 = pcreCompile( " " )
	out = pcreReplace( comPat1 t_fileName "\\\\ " 0 )
	comPat2 = pcreCompile( "\\&" )
	out = pcreReplace( comPat2 out "\\& " 0 )
	comPat3 = pcreCompile( "\\*" )
	out = pcreReplace( comPat3 out "\\* " 0 )
))

; HI treats cyclic ?callback return as callable — progn forces nil result.
procedure( UpdateFileContents(_field scope item)
	progn(
	  case(item
		(("Power Point (*.pptx)")
		 scope->FileNameField->value = strcat(buildString(reverse(cdr(reverse(parseString(scope->FileNameField->value ".")))) "") ".pptx"))
		(("Excel Spreadsheet (*.xlsx)")
		 scope->FileNameField->value = strcat(buildString(reverse(cdr(reverse(parseString(scope->FileNameField->value ".")))) "") ".xlsx"))
		(("PDF (*.pdf)")
		 scope->FileNameField->value = strcat(buildString(reverse(cdr(reverse(parseString(scope->FileNameField->value ".")))) "") ".pdf"))
		(("HTML (*.html)")
		 scope->FileNameField->value = strcat(buildString(reverse(cdr(reverse(parseString(scope->FileNameField->value ".")))) "") ".html"))
		(("Word Document (*.docx)")
		 scope->FileNameField->value = strcat(buildString(reverse(cdr(reverse(parseString(scope->FileNameField->value ".")))) "") ".docx"))
	  )
	  nil))

list(nil
	'CombinedGUI CombinedGUI
	'CreateViewFromFileGUI CreateViewFromFileGUI
))

putprop(VrtImport['Softworks] NewDocViewGUI 'NewDocViewGUI)
)
; Must be *outside* the package let: assigning inside the let can leave these
; scoped to the let, so SdmXLSX and lmgrCreateMenuItem callbacks cannot see them.
SdmCombinedGUI = VrtImport['Softworks]->NewDocViewGUI->CombinedGUI

; ddsLMCMenuItem prepends the menu-item action ID as the first argument before
; spreading the lib/cell/view selection context, giving 6 args total:
;   LMgr path:    (actionId lib cell view "" "")  — actionId is not a dd library
;   Direct path:  (lib cell view)                 — first arg is a dd library name
; Detect the convention via ddGetLib and route to CreateViewFromFileGUI accordingly.
procedure( SdmCreateViewFromFileGUI(@rest args)
  let(((fn VrtImport['Softworks]->NewDocViewGUI->CreateViewFromFileGUI)
       (a1 or(car(args)    ""))
       (a2 or(cadr(args)   ""))
       (a3 or(caddr(args)  ""))
       (a4 or(cadddr(args) "")))
    if(ddGetLib(a1)
      then fn(a1 a2 a3)
      else fn(a2 a3 a4))))
