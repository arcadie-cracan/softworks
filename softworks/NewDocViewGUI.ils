; Default path helper: delegates to SoftworksDocPathFillFromEnv (Softworks.ils).
; DEBASE GUICellView uses SoftworksDocImportPathResult + ?defValue — no prog2(local setq).
procedure(SoftworksNewDocViewFilePathDefault()
  SoftworksDocPathFillFromEnv()
  SoftworksDocImportPathResult)

; DEBASE: blankstrp may be absent on stripped stacks → eval: not a function - nil.
procedure(SoftworksBlankStringp(s)
  cond(
    ((neq stringp(s) nil) eq(strlen(s) 0))
    ((equal 0 0) nil)))

; Map lib/cell/view name or DEBASE rootType / viewType tag to xlsx|pptx|pdf|html|docx for doc GUI defaults.
procedure(SoftworksNormalizeDocKindTag(tagRaw)
	let(((tag ""))
	  tag = cond(
	    ((neq stringp(tagRaw) nil) tagRaw)
	    ((neq symbolp(tagRaw) nil) sprintf(nil "%s" tagRaw))
	    ((equal 0 0) ""))
	  cond(
	    ((neq tag "") cond(
	      ((neq member(tag '("xlsx" "pptx" "pdf" "html" "docx")) nil) tag)
	      ((neq member(tag '("pdf_view")) nil) "pdf")
	      ((equal 0 0) nil)))
	    ((equal 0 0) nil))))

let((NewDocViewGUI
	   (module_description "The Gui for creating and importing documentation views"))
NewDocViewGUI = let(((SoftworksNdDummy nil)
                    (docViewTypes '("pdf" "pptx" "xlsx" "html" "docx")))

; Shared: launch the external editor for a newly created/imported view.
procedure( launchDocEditor(fp ext)
  cond(
    ((equal ext "xlsx")
     let(((m VrtImport['Softworks]->XLSX))
       cond(((neq procedurep(m->startReader) nil) m->startReader(fp)))))
    ((equal ext "pptx")
     let(((m VrtImport['Softworks]->PPTX))
       cond(((neq procedurep(m->startReader) nil) m->startReader(fp)))))
    ((equal ext "pdf")
     let(((m VrtImport['Softworks]->PDF))
       cond(((neq procedurep(m->startReader) nil) m->startReader(fp)))))
    ((equal ext "html")
     ipcBeginProcess(strcat("firefox " fp) "" nil nil))
    ((equal ext "docx")
     let(((m VrtImport['Softworks]->DOCX))
       cond(((neq procedurep(m->startReader) nil) m->startReader(fp)))))))

; Returns the hiCreateFileSelectorField ?filter string for a given Softworks view type.
; Falls back to a broad document filter for unrecognised types.
procedure( sdmDocExtFilter(viewType)
  case(viewType
    (("pdf")  "PDF Files (*.pdf);;All Files (*)")
    (("pptx") "PowerPoint Files (*.pptx);;All Files (*)")
    (("xlsx") "Excel Files (*.xlsx *.xlsm);;All Files (*)")
    (("html") "HTML Files (*.html *.htm *.hml);;All Files (*)")
    (("docx") "Word Documents (*.docx);;All Files (*)")
    (t        "Document Files (*.pdf *.pptx *.xlsx *.html *.docx);;All Files (*)")))

; Maps a ContentsOption / DocTypeDropdown cyclic-field label to its bare file extension.
procedure( sdmContentsToExt(contentsValue)
  case(contentsValue
    (("Power Point (*.pptx)")       "pptx")
    (("Excel Spreadsheet (*.xlsx)") "xlsx")
    (("PDF (*.pdf)")                "pdf")
    (("HTML (*.html)")              "html")
    (("Word Document (*.docx)")     "docx")
    (t nil)))

; Reverse map: bare file extension → ContentsOption / DocTypeDropdown label.
; Used to auto-populate the dropdown when an existing view's file type is detected.
procedure( sdmExtToDocLabel(ext)
  case(ext
    (("pdf")  "PDF (*.pdf)")
    (("pptx") "Power Point (*.pptx)")
    (("xlsx") "Excel Spreadsheet (*.xlsx)")
    (("html") "HTML (*.html)")
    (("docx") "Word Document (*.docx)")
    (t nil)))

; Read the master filename from a view's master.tag file.
; ddGetObjWritePath on a view opened without a filename returns the view
; directory, not the master file path.  This function parses the second line of
; master.tag (which contains the bare filename, e.g. "datasheet.xlsx") instead.
; Returns the filename string or nil if master.tag is missing / unreadable.
procedure( sdmGetViewMasterFile(viewObj)
  let(((viewDir ddGetObjWritePath(viewObj)) p line)
    when(viewDir
      p = infile(strcat(viewDir "/master.tag"))
      when(p
        gets(line p)   ; skip "-- Master.tag File, Rev:1.0" header
        gets(line p)   ; master filename line
        close(p)
        car(parseString(line "\n\r \t"))))))

; Browse button callback for the import form.
; Opens a file chooser filtered to the extension currently selected in DocTypeDropdown.
; For existing views the dropdown is locked to the detected type, so the filter
; automatically matches the on-disk format.
procedure( browseSourceFileCB(field form)
  let(((ext    sdmContentsToExt(form->DocTypeDropdown->value))
       (filter sdmDocExtFilter(or(ext "")))
       (workDir or(form->FilePathField->value SoftworksDocImportPathResult pwd()))
       file)
    file = hiGetExistingFile(
      ?workingDir workDir
      ?filter     filter
      ?modal      t)
    when(file
      form->FilePathField->value =
        simplifyFilenameUnique(strcat(car(file) "/" cadr(file))))))

; ViewNameField callback — checks whether the view exists and updates the dialog state.
;
;   View exists with recognised extension  → lock DocTypeDropdown to detected type,
;                                            "Will overwrite existing cell view"
;   View absent                            → unlock DocTypeDropdown,
;                                            "Will create a new cell view"
procedure( checkViewExistsCB(field scope)
  let(((lib  scope->LibNameField->value)
       (cell scope->CellNameField->value)
       (view field->value)
       viewObj masterPath ext docLabel)
    when(view != ""
      viewObj = when(lib != "" && cell != ""
        ddGetObj(lib cell view nil nil "r"))
      if(viewObj then
        ; ── Existing view: detect type from master-file extension ──────────
        ext      = car(reverse(parseString(
                     or(sdmGetViewMasterFile(viewObj) "") ".")))
        docLabel = sdmExtToDocLabel(ext)
        when(docLabel
          scope->DocTypeDropdown->value   = docLabel
          scope->DocTypeDropdown->enabled = nil)
        scope->FilePathField->enabled    = t
        scope->BrowseButton->enabled     = t
        scope->ImportModeLabel->value    = "Will overwrite existing cell view"
      else
        ; ── New view: let user pick the document type ──────────────────────
        scope->DocTypeDropdown->enabled  = t
        scope->FilePathField->enabled    = t
        scope->BrowseButton->enabled     = t
        scope->ImportModeLabel->value    = "Will create a new cell view")))
  nil)

; Callback for the New Documentation Cell View form (DataTrigger path).
; Creates a blank cell view from a template and launches the editor.
; FileName is derived as CellName + "." + extension (e.g. "Design_Manual.pptx").
procedure( createViewCB( form )
let((LibName CellName ViewName FileName ext viewFileObj cpSuccess)
	if( form == nil then
		form = hiGetCurrentForm()
	)
	LibName  = form->LibNameField->value
	CellName = form->CellNameField->value
	ViewName = form->ViewNameField->value
	ext      = sdmContentsToExt(form->ContentsOption->value)
	unless(ext
		error("Unrecognised file type selection: %s" form->ContentsOption->value))
	FileName = strcat(CellName "." ext)
	viewFileObj = ddGetObj(LibName CellName ViewName FileName nil "w")
	if(viewFileObj == nil then
		error("Cannot create cell view %s %s %s with file name %s" LibName CellName ViewName FileName)
	)
	let(((templatePath nil) (writePath viewFileObj~>writePath))
	  case(form->ContentsOption->value
		(("Power Point (*.pptx)")
			templatePath = softworksBlankDocTemplatePath("pptx/pptxTemplate.pptx"))
		(("Excel Spreadsheet (*.xlsx)")
			templatePath = softworksBlankDocTemplatePath("xlsx/xlsxTemplate.xlsx"))
		(("PDF (*.pdf)")
			templatePath = softworksBlankDocTemplatePath("pdf/pdfTemplate.pdf"))
		(("HTML (*.html)")
			templatePath = softworksBlankDocTemplatePath("html/htmlTemplate.html"))
		(("Word Document (*.docx)")
			templatePath = softworksBlankDocTemplatePath("docx/docxTemplate.docx"))
	  )
	  let(((sourcePath templatePath))
	    cond(
		  ((neq isReadable(templatePath) t)
		   warn("Softworks: template %s not found; falling back to built-in template." templatePath)
		   sourcePath = strcat(SoftworksInstallDir "/templates/" car(reverse(parseString(templatePath "/"))))))
	    cpSuccess = shell(strcat("cp -f " EscapeSpecialCharacters(sourcePath) " " EscapeSpecialCharacters(writePath)))
	    if(not(cpSuccess) then
		  error("The file copy failed.  Could not copy template %s to %s" sourcePath writePath)
	    else
		  printf("Created %s %s %s cell view from template %s\n" LibName CellName ViewName sourcePath)
	    )
	  )
	)
	ddUpdateLibList()
	hiSetCallbackStatus(form t)
	hiFormUnmap(form)
	cond(
	  ((neq cpSuccess nil)
	   launchDocEditor(viewFileObj~>writePath ext)))
))

; Callback for the Import Document as Cell View form (Library Manager path).
; FileName is derived automatically — not read from a form field:
;   Existing view  →  basename of ddGetObjWritePath (preserves the on-disk name)
;   New view       →  CellName + "." + ext  (e.g. "Design_Manual.xlsx")
; The file extension comes from DocTypeDropdown, NOT from the view name, so any
; view name (e.g. "datasheet", "installation_guide") works correctly.
procedure( createViewFromFileCB( form )
let((LibName CellName ViewName FileName FilePath ext viewFileObj overwrite cpSuccess)
	if( form == nil then
		form = hiGetCurrentForm()
	)
	LibName  = form->LibNameField->value
	CellName = form->CellNameField->value
	ViewName = form->ViewNameField->value
	FilePath = form->FilePathField->value
	ext      = sdmContentsToExt(form->DocTypeDropdown->value)
	unless(ext
		error("No document type selected — please choose a type before importing."))
	; Validate the source file has a supported extension.
	if(!CheckExtension(FilePath)
		error("Source file '%s' does not have a supported document extension" FilePath)
	)
	; Re-check existence at OK time rather than reading the display label.
	viewFileObj = ddGetObj(LibName CellName ViewName nil nil "r")
	if(viewFileObj then
		; ── Overwrite existing ───────────────────────────────────────────
		FileName   = sdmGetViewMasterFile(viewFileObj)
		overwrite  = hiDisplayAppDBox(
			?name 'OverwriteDBox
			?dboxBanner "Overwrite Existing Cell View?"
			?dboxText strcat("Do you want to overwrite the following existing cell view?\nLib: " LibName "\nCell: " CellName "\nView: " ViewName)
			)
		when(overwrite && ddNeedCheckout(viewFileObj)
			ddCheckout(viewFileObj))
	else
		; ── New cell view ────────────────────────────────────────────────
		FileName  = strcat(CellName "." ext)
		overwrite = t
	) ; if viewFileObj
	when(overwrite
		viewFileObj = ddGetObj(LibName CellName ViewName FileName nil "w")
		cpSuccess = shell(strcat("cp -f " EscapeSpecialCharacters(FilePath) " " viewFileObj~>writePath))
		if(not(cpSuccess) then
			error("The file copy failed.  Could not copy %s to %s" EscapeSpecialCharacters(FilePath) viewFileObj~>writePath)
		else
			printf("Imported %s as %s %s %s cell view\n" FilePath LibName CellName ViewName)
		)
	)
	ddUpdateLibList()
	hiSetCallbackStatus(form t)
	hiFormUnmap(form)
	cond(
	  ((neq cpSuccess nil)
	   launchDocEditor(viewFileObj~>writePath ext)))
))

; DataTrigger path: open when view doesn't exist — New cell view only.
procedure( CombinedGUI(LibSelected CellSelected ViewSelected @optional RootTypeHint)
let((SelectionL newForm formName)
	SoftworksDocPathFillFromEnv()
	SelectionL = GUICellView(LibSelected CellSelected ViewSelected RootTypeHint)
	formName = gensym('newDocViewForm)
	newForm = hiCreateAppForm(
		?name formName
		?formTitle "New Documentation Cell View"
		?fields car(SelectionL)
		?buttonLayout 'OKCancelApply
		?callback createViewCB
		?unmapAfterCB t
	)
	hiInstantiateForm(newForm)
	; Link only Lib→Cell; ViewNameField is free-text (allowAny) and must keep ViewSelected.
	ddHiLinkFields(
		newForm->LibNameField
		newForm->CellNameField
	)
	hiDisplayForm( newForm )
	nil
))

; Library Manager path: import an existing file into either an existing or new cell view.
; The view name is free-form — any string is valid. Dispatch to the correct viewer is
; driven by the file extension written into master.tag, not by the view name.
procedure( CreateViewFromFileGUI(@optional (LibSelected "") (CellSelected "") (ViewSelected ""))
let((SelectionL newForm formName existingViewObj existingExt
     initialDocLabel initialDocTypeEnabled initialLabel)
	SoftworksDocPathFillFromEnv()
	; Check whether the pre-selected cell view already exists.
	existingViewObj = nil
	when(LibSelected != "" && CellSelected != "" && ViewSelected != ""
		existingViewObj = ddGetObj(LibSelected CellSelected ViewSelected nil nil "r"))
	; For an existing view, determine its type from the master-file extension.
	; If the extension is unrecognised (non-Softworks), refuse to open the form.
	existingExt = nil
	when(existingViewObj
		existingExt = car(reverse(parseString(
		                or(sdmGetViewMasterFile(existingViewObj) "") ".")))
		unless(sdmExtToDocLabel(existingExt)
		  warn("[Softworks] Cannot import into %s / %s / %s: unrecognized file extension '%s'."
		       LibSelected CellSelected ViewSelected existingExt)
		  existingExt = nil))
	if(existingViewObj && not(existingExt) then
		nil ; blocked — existing view with unrecognised extension
	else
		; Initial document-type dropdown value and enabled state.
		initialDocLabel =
		  if(existingExt
		    then sdmExtToDocLabel(existingExt)
		    else or(sdmExtToDocLabel(SoftworksNormalizeDocKindTag(ViewSelected))
		            "PDF (*.pdf)"))
		initialDocTypeEnabled = not(existingViewObj)
		; Initial status label.
		initialLabel =
		  if(existingViewObj
		    then "Will overwrite existing cell view"
		    else "Will create a new cell view")
		SelectionL = nil
		SelectionL = tconc(SelectionL list(ddHiCreateLibraryComboField(
			?name       'LibNameField
			?prompt     "Library"
			?defValue    LibSelected
			?toolTip    "Library Name"
			?validationType  'allowExisting
			?editable  t)
			5:10 400:30 60))
		SelectionL = tconc(SelectionL list(ddHiCreateCellComboField(
			?name      'CellNameField
			?prompt    "Cell"
			?defValue   CellSelected
			?toolTip    "Cell Name"
			?validationType  'allowAny
			?editable    t)
			5:50 400:30 60))
		; checkViewExistsCB fires on view name change: auto-detects document type
		; from the master-file extension of any existing view and locks/unlocks the
		; DocTypeDropdown accordingly.
		SelectionL = tconc(SelectionL list(ddHiCreateViewComboField(
			?name      'ViewNameField
			?prompt    "View"
			?defValue  ViewSelected
			?toolTip   "View Name — any string is valid (e.g. datasheet, installation_guide)"
			?validationType  'allowAny
			?callback  checkViewExistsCB
			?editable   t)
			5:90 400:30 60))
		; DocTypeDropdown: user-selectable for new views; auto-detected and locked for existing views.
		SelectionL = tconc(SelectionL list(hiCreateCyclicField(
			?name      'DocTypeDropdown
			?choices   '("PDF (*.pdf)"
			             "Power Point (*.pptx)"
			             "Excel Spreadsheet (*.xlsx)"
			             "HTML (*.html)"
			             "Word Document (*.docx)")
			?defValue  initialDocLabel
			?prompt    "Document Type"
			?enabled   initialDocTypeEnabled)
			5:130 400:30 90))
		; Read-only status label: tells the user what will happen on OK.
		SelectionL = tconc(SelectionL list(hiCreateStringField(
			?name      'ImportModeLabel
			?prompt    "Action"
			?defValue  initialLabel
			?editable  nil
			?enabled   t)
			5:170 400:30 90))
		SelectionL = tconc(SelectionL list(hiCreateStringField(
			?name     'FilePathField
			?prompt   "Source File"
			?defValue  SoftworksDocImportPathResult
			?editable  t)
			5:210 365:30 100))
		SelectionL = tconc(SelectionL list(hiCreateButton(
			?name       'BrowseButton
			?buttonText "Browse..."
			?callback   browseSourceFileCB)
			375:210 85:30 60))
		; FileName is derived automatically at OK time (not a form field):
		;   Existing view  →  basename of ddGetObjWritePath (preserves the on-disk name)
		;   New view       →  CellName + "." + DocTypeDropdown extension
		formName = gensym('importFileDocForm)
		newForm = hiCreateAppForm(
			?name formName
			?formTitle "Import Document as Cell View"
			?fields car(SelectionL)
			?buttonLayout 'OKCancelApply
			?callback createViewFromFileCB
			?unmapAfterCB t
		)
		hiInstantiateForm(newForm)
		ddHiLinkFields(
			newForm->LibNameField
			newForm->CellNameField
			newForm->ViewNameField
		)
		; Set field values after linking/instantiation so they are not cleared.
		newForm->ViewNameField->value   = ViewSelected
		newForm->DocTypeDropdown->value = initialDocLabel
		hiDisplayForm( newForm )
		nil
	) ; if existingViewObj && not(existingExt)
))

; Build the New-view form fields (used by CombinedGUI).
procedure( GUICellView(LibSelected CellSelected ViewSelected @optional RootTypeHint)
  let((SelectionL viewTag viewDocKind docKind unknownDocKind contentsDef)
	SelectionL = nil
	viewTag = cond(
	  ((neq stringp(ViewSelected) nil) ViewSelected)
	  ((neq symbolp(ViewSelected) nil) sprintf(nil "%s" ViewSelected))
	  ((equal 0 0) ""))
	viewDocKind = SoftworksNormalizeDocKindTag(viewTag)
	docKind = cond(
	  ((neq viewDocKind nil) viewDocKind)
	  ((equal 0 0) SoftworksNormalizeDocKindTag(RootTypeHint)))
	unknownDocKind = nil
	cond(
	  ((eq docKind nil) unknownDocKind = 'SoftworksUnknownDocKind)
	  ((neq SoftworksBlankStringp(docKind) nil) unknownDocKind = 'SoftworksUnknownDocKind))
	contentsDef = cond(
	  ((neq unknownDocKind nil) "Power Point (*.pptx)")
	  ((neq member(docKind '("xlsx")) nil) "Excel Spreadsheet (*.xlsx)")
	  ((neq member(docKind '("pptx")) nil) "Power Point (*.pptx)")
	  ((neq member(docKind '("pdf")) nil) "PDF (*.pdf)")
	  ((neq member(docKind '("html")) nil) "HTML (*.html)")
	  ((neq member(docKind '("docx")) nil) "Word Document (*.docx)")
	  ((equal 0 0) "Power Point (*.pptx)"))
	; LIB, CELL, VIEW SELECTION
	SelectionL = tconc(SelectionL list(ddHiCreateLibraryComboField(
		?name       'LibNameField
		?prompt     "Library"
		?defValue    LibSelected
		?toolTip    "Library Name"
		?validationType  'allowExisting
		?editable  t)
		5:10 400:30 60))
	SelectionL = tconc(SelectionL list(ddHiCreateCellComboField(
		?name      'CellNameField
		?prompt    "Cell"
		?defValue   CellSelected
		?toolTip    "Cell Name"
		?validationType  'allowAny
		?editable    t)
		5:50 400:30 60))
	SelectionL = tconc(SelectionL list(ddHiCreateViewComboField(
		?name      'ViewNameField
		?prompt    "View"
		?defValue  ViewSelected
		?toolTip       "View Name"
		?validationType  'allowAny
		?editable   t)
		5:90 400:30 60))
	; FileNameField removed: FileName = CellName + "." + ext is derived in createViewCB.
	SelectionL = tconc(SelectionL list(hiCreateCyclicField(
		?name       'ContentsOption
		?choices    '("Power Point (*.pptx)" "Excel Spreadsheet (*.xlsx)" "PDF (*.pdf)" "HTML (*.html)" "Word Document (*.docx)")
		?defValue   contentsDef
		?callback   UpdateFileContents
		?prompt     "File Type"
		?enabled   t
		?keepHistory t)
		5:170 400:30 100))
	SelectionL
))

procedure( CheckExtension(file)
	strcmp(substring(file -5) ".pptx") ||
	strcmp(substring(file -4) ".pdf") ||
	strcmp(substring(file -5) ".xlsx") ||
	strcmp(substring(file -5) ".xlsm") ||
	strcmp(substring(file -4) ".mdf") ||
	strcmp(substring(file -4) ".txt") ||
	strcmp(substring(file -4) ".hml") ||
	strcmp(substring(file -5) ".html") ||
	strcmp(substring(file -5) ".docx")
)

procedure( EscapeSpecialCharacters(t_fileName)
let( (comPat1 comPat2 comPat3 out)
	comPat1 = pcreCompile( " " )
	out = pcreReplace( comPat1 t_fileName "\\\\ " 0 )
	comPat2 = pcreCompile( "\\&" )
	out = pcreReplace( comPat2 out "\\& " 0 )
	comPat3 = pcreCompile( "\\*" )
	out = pcreReplace( comPat3 out "\\* " 0 )
))

; ContentsOption callback: keeps ViewNameField in sync with the selected file type.
; HI treats cyclic ?callback return as callable — progn forces nil result.
procedure( UpdateFileContents(_field scope item)
	progn(
	  let(((ext sdmContentsToExt(item)))
	    when(ext
	      scope->ViewNameField->value = ext))
	  nil))

list(nil
	'CombinedGUI CombinedGUI
	'CreateViewFromFileGUI CreateViewFromFileGUI
	'checkViewExistsCB checkViewExistsCB
))

putprop(VrtImport['Softworks] NewDocViewGUI 'NewDocViewGUI)
)
; Must be *outside* the package let: assigning inside the let can leave these
; scoped to the let, so SdmXLSX and lmgrCreateMenuItem callbacks cannot see them.
SdmCombinedGUI = VrtImport['Softworks]->NewDocViewGUI->CombinedGUI

; ddsLMCMenuItem prepends the menu-item action ID as the first argument before
; spreading the lib/cell/view selection context, giving 6 args total:
;   LMgr path:    ("ImportDocAsView" lib cell view "" "")
;   Direct path:  (lib cell view)
; The action ID is the sentinel: when arg1 matches it we shift the window by 1.
procedure( SdmCreateViewFromFileGUI(@rest args)
  let(((fn VrtImport['Softworks]->NewDocViewGUI->CreateViewFromFileGUI)
       (a1 or(car(args)    ""))
       (a2 or(cadr(args)   ""))
       (a3 or(caddr(args)  ""))
       (a4 or(cadddr(args) "")))
    if(equal(a1 "ImportDocAsView")
      then fn(a2 a3 a4)
      else fn(a1 a2 a3))))
