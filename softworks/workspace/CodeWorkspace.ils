let((CodeWorkspace)

CodeWorkspace = let(((Path VrtImport['Path])
	(Softworks VrtImport['Softworks]))

procedure(init()
  let((target exe f port line rootReady)
    ; create or refresh the code workspace unless already materialized
    target = getShellEnvVar("SOFTWORKS_VSCODE_WORKSPACE")
    unless(target
      target = strcat(Softworks->softworksEffectiveProjectRoot() "/softworks_workspace"))
    exe = "python -m softworks.workspace.code_workspace"
    cond(
      ; target is a .code-workspace file
      (strlen(target) >= 16 && zerop(strcmp(substring(target -16) ".code-workspace"))
        rootReady = nil
        when(isFile(target)
          f = sprintf(nil "/tmp/sw_ws_root_%s_%d"
            getShellEnvVar("USER") random(1000000))
          system(sprintf(nil "%s --print-root > \"%s\"" exe f))
          when(isReadable(f)
            port = infile(f)
            line = gets(port)
            close(port)
            when(line && isDir(line)
              rootReady = t))
        )
        unless(rootReady
          printf("  Creating the softworks workspace...")
          system(exe)
          printf("done\n"))
      )
      (!isDir(target)
        printf("  Creating the softworks workspace...")
        createDirHier(target)
        system(exe)
        printf("done\n")
        unless(isDir(target)
          warn(sprintf(nil
            "    Could not create workspace directory (SOFTWORKS_VSCODE_WORKSPACE): %s"
            target)))
      )
    )
  )
)

list(nil
	'init init
))

CodeWorkspace->init()

)
