printf("  Loading Softworks core...")

let((Softworks
  (module_description "Software and documentation view types in the Cadence Virtuoso IC design environment"))

Softworks = let(()

; A trigger that does nothing and is commonly used for the app and enable triggers.
procedure(IdleTrigger(@optional argList)
	;Do Nothing
	t)

; Open a view in the gedit text editor
procedure(startGedit(@rest restArgs)
	if(restArgs then
		system(sprintf(nil "gedit %s &" buildString(restArgs)))
	else
		system("gedit &"))
)

procedure(deRegSdmApp(viewType appName dataTrigger @optional (parentType nil))
	cond(
	(member(viewType deGetAllViewTypes())
		warn("Already defined the \"%s\" view type, need to run uninit before redefining it." viewType))
	(dataTrigger
		deRegApp( ; Primary type
	    	?appName appName
	    	?enableTrigger 'SdmIdleTrigger
	    	?dataTrigger stringToSymbol(dataTrigger)
	    	?viewType viewType
			?appTrigger 'SdmIdleTrigger
	    	?widgetType "none"
	  	)
	)
	(parentType ; subtype
		deRegApp(
	    	?appName appName
	    	?enableTrigger 'SdmIdleTrigger
	    	?parentType parentType
	    	?viewType viewType
	    	?widgetType "none"
	  	)
	)
	(t warn("Either the dataTrigger or parentType must be specified for view type" viewType)))
)

; Initialize All the custom cellviews contained in viewSetup
;  viewSetup is a list with each element containing the definition for a view with the form:
;   list(viewType  appName dataTrigger parentType)
; Each view type is always attempted regardless of whether earlier ones fail or are already
; registered — avoiding silent skip of later types via short-circuit evaluation.
procedure(initDeRegApp(viewSetup) let(((out t))
	foreach(app viewSetup
		unless(deRegSdmApp(car(app) cadr(app) caddr(app) cadddr(app))
			out = nil)
	)
	out
))

; uninitialize all Python views so they can be redefined
procedure(uninitDeRegApp(viewSetup) let(((out t))
	foreach(view viewSetup
		when(member(car(view) deGetAllViewTypes())
			out = out && deUnRegApp(car(view)))
	)
	out
))

; Effective project root: SOFTWORKS_PROJECT_ROOT when set, else pwd().
procedure(softworksEffectiveProjectRoot()
  "Returns the project root directory string: SOFTWORKS_PROJECT_ROOT, or pwd() if unset."
  let(((r (getShellEnvVar("SOFTWORKS_PROJECT_ROOT"))))
    if(r then r else pwd()))
)

; Parent of pptx/, xlsx/, pdf/, html/ blank-document templates.
; SOFTWORKS_TEMPLATES_DIR when set and non-empty; else SOFTWORKS_ROOT/src (legacy).
procedure(softworksTemplatesRoot()
  "Returns template root dir string or nil if neither env var can provide a path."
  let(((td (getShellEnvVar("SOFTWORKS_TEMPLATES_DIR")))
       (root (getShellEnvVar("SOFTWORKS_ROOT"))))
    if(td && greaterp(strlen(td) 0) then
      td
    else
      if(root && greaterp(strlen(root) 0) then
        strcat(root "/src")
      else
        progn(
          warn("Softworks: SOFTWORKS_TEMPLATES_DIR is unset and SOFTWORKS_ROOT is unset; blank doc template copy will fail.")
          nil)))))

procedure(softworksBlankDocTemplatePath(relativeTemplatePath "s")
  "Full path to a file under the template root, e.g. \"xlsx/xlsxTemplate.xlsx\"."
  let(((base nil))
    progn(
      base = softworksTemplatesRoot()
      if(base then
	strcat(base "/" relativeTemplatePath)
      else
	error("Softworks: cannot resolve blank document templates; set SOFTWORKS_TEMPLATES_DIR or SOFTWORKS_ROOT.")))))

; Default directory for documentation import GUIs (PPTX/PDF/etc. file picker start path).
; SOFTWORKS_DOC_DIR overrides; otherwise <effective project root>/doc/ (warn if both override env vars unset).
procedure(softworksProjectDocDir()
  "Returns a directory path ending in / for the documentation import file picker default."
  let(((explicit (getShellEnvVar("SOFTWORKS_DOC_DIR")))
       (root nil))
    if(explicit && greaterp(strlen(explicit) 0) then
      strcat(explicit "/")
    else
      progn(
	root = softworksEffectiveProjectRoot()
	if(getShellEnvVar("SOFTWORKS_PROJECT_ROOT") then
	  strcat(root "/doc/")
	else
	  progn(
	    warn(sprintf(nil
	      "Softworks: SOFTWORKS_DOC_DIR and SOFTWORKS_PROJECT_ROOT are not set; using the default doc import path %s/doc/ (current working directory as project root)."
	      pwd()))
	    strcat(root "/doc/")
	  )
	)
      )
    )
  )
)

; Optional CIW tracing: set shell env SOFTWORKS_DEBUG to any non-empty string before Virtuoso.
procedure(softworksDebugEnabled()
  let(((v (getShellEnvVar("SOFTWORKS_DEBUG"))))
    if(v then greaterp(strlen(v) 0) else nil)))

procedure(softworksDebugWarn(msg)
  "Emit one line to CIW via warn when SOFTWORKS_DEBUG is set (msg should be a single string)."
  let(((v (getShellEnvVar("SOFTWORKS_DEBUG"))))
    when(v
      when(greaterp(strlen(v) 0)
        warn(strcat("Softworks DEBUG: " msg))))))

; Alist/Import *->* accessors can be nil on some builds; NewDocViewGUI and others need these
; globals to be real procedures. Value-cell assignment is not enough in SKILL++: calls like
; softworksProjectDocDir() use the function obarray; use putd to register the funobj.
SdmIdleTrigger = IdleTrigger
softworksProjectDocDir = softworksProjectDocDir
SoftworksProjectDocDir = softworksProjectDocDir
softworksEffectiveProjectRoot = softworksEffectiveProjectRoot
SoftworksEffectiveProjectRoot = softworksEffectiveProjectRoot
softworksTemplatesRoot = softworksTemplatesRoot
SoftworksTemplatesRoot = softworksTemplatesRoot
softworksBlankDocTemplatePath = softworksBlankDocTemplatePath
SoftworksBlankDocTemplatePath = softworksBlankDocTemplatePath
softworksDebugEnabled = softworksDebugEnabled
softworksDebugWarn = softworksDebugWarn
putd('SdmIdleTrigger IdleTrigger)
putd('softworksProjectDocDir softworksProjectDocDir)
putd('SoftworksProjectDocDir softworksProjectDocDir)
putd('softworksEffectiveProjectRoot softworksEffectiveProjectRoot)
putd('SoftworksEffectiveProjectRoot softworksEffectiveProjectRoot)
putd('softworksTemplatesRoot softworksTemplatesRoot)
putd('SoftworksTemplatesRoot softworksTemplatesRoot)
putd('softworksBlankDocTemplatePath softworksBlankDocTemplatePath)
putd('SoftworksBlankDocTemplatePath softworksBlankDocTemplatePath)
putd('softworksDebugEnabled softworksDebugEnabled)
putd('softworksDebugWarn softworksDebugWarn)

list(nil
	'IdleTrigger IdleTrigger
	'startGedit startGedit
	'deRegSdmApp deRegSdmApp
	'initDeRegApp initDeRegApp
	'uninitDeRegApp uninitDeRegApp
	'softworksProjectDocDir softworksProjectDocDir
	'softworksEffectiveProjectRoot softworksEffectiveProjectRoot
	'softworksTemplatesRoot softworksTemplatesRoot
	'softworksBlankDocTemplatePath softworksBlankDocTemplatePath
	'softworksDebugEnabled softworksDebugEnabled
	'softworksDebugWarn softworksDebugWarn
))

Softworks = Import['Module]->New('Softworks
              ?module Softworks
              ?package Softworks
              ?description module_description)
)
; SdmIdleTrigger and softworks* globals are set on the alist before list() above; do not
; rebind from Import['Softworks]->* here (can be nil and break GUICellView / defValue).

; Safe documentation import default directory for contexts where calling
; softworksProjectDocDir() fails ("not a function - nil" with HI ?defValue / SKILL++).
; Mirrors env/root/pwd logic using getShellEnvVar / strcat / pwd only — no d().
; DEBASE: avoid cond arms that expose env path strings + avoid setq value leaking as functor —
; Store uses eval(list 'setq ...) inside progn so this procedure always yields nil; FillFromEnv
; uses only zero-arg branches at the top cond so no long strings flow through cond lowering.
;
; [Softworks DOCPATH] DPstepNN: same env switches as GVstep (cannot rely on boundp of
; SoftworksGUICellViewStepTraceP — symbol may live only on Import path).
SoftworksDocImportPathResult = nil

procedure(SoftworksDocPathTraceP()
  cond(
    ((neq nil getShellEnvVar("SOFTWORKS_GUI_TRACE")) 1)
    ((neq nil getShellEnvVar("SOFTWORKS_TRIGGER_TRACE")) 1)
    ((neq nil getShellEnvVar("SOFTWORKS_DEBUG")) 1)
    ((neq nil getShellEnvVar("SOFTWORKS_NEW_DOC_GUI_DEBUG")) 1)
    ((neq nil getShellEnvVar("SOFTWORKS_GUICELLVIEW_DEBASE_STEP")) 1)
    ((equal 0 0) nil)))

procedure(SoftworksDocPathDbg(msg)
  cond(((neq SoftworksDocPathTraceP() nil) warn(strcat("[Softworks DOCPATH] " msg)))))

; DEBASE: never use if(strVar then ...) when strVar can be SOFTWORKS_DOC_DIR — functor bug.
procedure(SoftworksDocPathDbgStrlen(s)
  cond(((equal nil s) -1) ((equal 0 0) strlen(s))))

procedure(SoftworksDocPathStore(v)
  progn(
    nil
    SoftworksDocPathDbg(sprintf(nil "DP20 SoftworksDocPathStore arg nil=%L len=%d"
      equal(nil v)
      SoftworksDocPathDbgStrlen(v)))
    progn(eval(list 'setq 'SoftworksDocImportPathResult v) nil)
    SoftworksDocPathDbg("DP21 SoftworksDocPathStore after eval(setq)")))

procedure(SoftworksDocPathApplyDocEnvSlash(docEnvDir)
  progn(
    nil
    SoftworksDocPathDbg("DP30 SoftworksDocPathApplyDocEnvSlash enter")
    SoftworksDocPathStore(strcat(docEnvDir "/"))
    SoftworksDocPathDbg("DP31 SoftworksDocPathApplyDocEnvSlash exit")))

procedure(SoftworksDocPathApplyRootDoc(rootDir)
  progn(
    nil
    SoftworksDocPathDbg("DP32 SoftworksDocPathApplyRootDoc enter")
    SoftworksDocPathStore(strcat(rootDir "/doc/"))
    SoftworksDocPathDbg("DP33 SoftworksDocPathApplyRootDoc exit")))

procedure(SoftworksDocPathApplyPwdDocWarn()
  progn(
    nil
    SoftworksDocPathDbg("DP40 SoftworksDocPathApplyPwdDocWarn enter")
    warn(sprintf(nil
      "Softworks: SOFTWORKS_DOC_DIR and SOFTWORKS_PROJECT_ROOT are not set; using the default doc import path %s/doc/ (current working directory as project root)."
      pwd()))
    SoftworksDocPathStore(strcat(pwd() "/doc/"))
    SoftworksDocPathDbg("DP41 SoftworksDocPathApplyPwdDocWarn exit")))

; Returns t when SOFTWORKS_DOC_DIR yields a usable path (side effect: stores path).
; DEBASE: no let(docEnv)/sprintf(docEnv)/equal(docEnv ...) — env string only inside
; getShellEnvVar("...") actuals and strcat(getShellEnvVar(...) "/") inside Store.
; DEBASE: progn(Dbg …) lets Dbg's nil apply to rest — lead each progn with nil.
procedure(SoftworksDocPathFillFromDocEnvVar()
  progn(
    nil
    SoftworksDocPathDbg("DP10 FillFromDocEnvVar (SOFTWORKS_DOC_DIR)")
    cond(
      ((equal nil getShellEnvVar("SOFTWORKS_DOC_DIR"))
	progn(SoftworksDocPathDbg("DP14 FillFromDocEnvVar SOFTWORKS_DOC_DIR unset") nil))
      ((equal(strlen(getShellEnvVar("SOFTWORKS_DOC_DIR")) 0))
	progn(SoftworksDocPathDbg("DP13 FillFromDocEnvVar skip empty SOFTWORKS_DOC_DIR") nil))
      (t
	progn(
	  nil
	  SoftworksDocPathDbg("DP11 FillFromDocEnvVar store strcat(SOFTWORKS_DOC_DIR /)")
	  SoftworksDocPathStore(strcat(getShellEnvVar("SOFTWORKS_DOC_DIR") "/"))
	  SoftworksDocPathDbg("DP12 FillFromDocEnvVar stored")
	  t)))))

; Returns t when SOFTWORKS_PROJECT_ROOT yields a usable path (side effect: stores path).
procedure(SoftworksDocPathFillFromRootEnvVar()
  progn(
    nil
    SoftworksDocPathDbg("DP50 FillFromRootEnvVar (SOFTWORKS_PROJECT_ROOT)")
    cond(
      ((equal nil getShellEnvVar("SOFTWORKS_PROJECT_ROOT"))
	progn(SoftworksDocPathDbg("DP54 FillFromRootEnvVar SOFTWORKS_PROJECT_ROOT unset") nil))
      ((equal(strlen(getShellEnvVar("SOFTWORKS_PROJECT_ROOT")) 0))
	progn(SoftworksDocPathDbg("DP53 FillFromRootEnvVar skip empty SOFTWORKS_PROJECT_ROOT") nil))
      (t
	progn(
	  nil
	  SoftworksDocPathDbg("DP51 FillFromRootEnvVar store .../doc/")
	  SoftworksDocPathStore(strcat(getShellEnvVar("SOFTWORKS_PROJECT_ROOT") "/doc/"))
	  SoftworksDocPathDbg("DP52 FillFromRootEnvVar stored")
	  t)))))

procedure(SoftworksDocPathFillFromEnv()
  progn(nil
    SoftworksDocPathDbg("DP01 SoftworksDocPathFillFromEnv enter")
    let(((hitDoc (SoftworksDocPathFillFromDocEnvVar())))
      progn(nil
	cond(((neq SoftworksDocPathTraceP() nil)
	  warn(sprintf(nil "[Softworks DOCPATH] DP02 FillFromDocEnvVar returned %L" hitDoc))))
	cond(
	  ((neq hitDoc nil)
	    progn(SoftworksDocPathDbg("DP03 branch doc-env satisfied") nil))
	  ((neq SoftworksDocPathFillFromRootEnvVar() nil)
	    progn(SoftworksDocPathDbg("DP04 branch root/doc satisfied") nil))
	  (t
	    progn(SoftworksDocPathDbg("DP05 branch pwd/doc fallback") SoftworksDocPathApplyPwdDocWarn() nil)))
	SoftworksDocPathDbg("DP09 SoftworksDocPathFillFromEnv exit")
	nil))))

procedure(SoftworksInvokeProjectDocDir()
  SoftworksDocPathFillFromEnv()
  SoftworksDocImportPathResult)
putd('SoftworksInvokeProjectDocDir SoftworksInvokeProjectDocDir)

printf("done\n")
