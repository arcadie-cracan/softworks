printf("  Loading Softworks core...")

procedure(SoftworksInstallDirFromPiport()
  let(((fp simplifyFilename(get_filename(piport))))
    strcat("/" buildString(reverse(cdr(reverse(parseString(fp "/")))) "/"))
))

; Captured at load time while piport still points to this file.
SoftworksInstallDir = SoftworksInstallDirFromPiport()

let((Softworks
  (module_description "Software and documentation view types in the Cadence Virtuoso IC design environment"))

Softworks = let(()

; A trigger that does nothing and is commonly used for the app and enable triggers.
procedure(IdleTrigger(@optional argList)
	;Do Nothing
	t)

; Open a view in the gedit text editor
procedure(startGedit(@rest restArgs)
	if(restArgs then
		system(sprintf(nil "gedit %s &" buildString(restArgs)))
	else
		system("gedit &"))
)

procedure(deRegSdmApp(viewType appName dataTrigger @optional (parentType nil))
	cond(
	(member(viewType deGetAllViewTypes())
		warn("Already defined the \"%s\" view type, need to run uninit before redefining it." viewType))
	(dataTrigger
		deRegApp( ; Primary type
	    	?appName appName
	    	?enableTrigger 'SdmIdleTrigger
	    	?dataTrigger stringToSymbol(dataTrigger)
	    	?viewType viewType
			?appTrigger 'SdmIdleTrigger
	    	?widgetType "none"
	  	)
	)
	(parentType ; subtype
		deRegApp(
	    	?appName appName
	    	?enableTrigger 'SdmIdleTrigger
	    	?parentType parentType
	    	?viewType viewType
	    	?widgetType "none"
	  	)
	)
	(t warn("Either the dataTrigger or parentType must be specified for view type" viewType)))
)

; Initialize All the custom cellviews contained in viewSetup
;  viewSetup is a list with each element containing the definition for a view with the form:
;   list(viewType  appName dataTrigger parentType)
; Each view type is always attempted regardless of whether earlier ones fail or are already
; registered — avoiding silent skip of later types via short-circuit evaluation.
procedure(initDeRegApp(viewSetup) let(((out t))
	foreach(app viewSetup
		unless(deRegSdmApp(car(app) cadr(app) caddr(app) cadddr(app))
			out = nil)
	)
	out
))

; uninitialize all Python views so they can be redefined
procedure(uninitDeRegApp(viewSetup) let(((out t))
	foreach(view viewSetup
		when(member(car(view) deGetAllViewTypes())
			out = out && deUnRegApp(car(view)))
	)
	out
))

; Effective project root: SOFTWORKS_PROJECT_ROOT when set, else pwd().
procedure(softworksEffectiveProjectRoot()
  "Returns the project root directory string: SOFTWORKS_PROJECT_ROOT, or pwd() if unset."
  let(((r getShellEnvVar("SOFTWORKS_PROJECT_ROOT")))
    if(r then r else pwd()))
)

; Parent of pptx/, xlsx/, pdf/, html/ blank-document templates.
; SOFTWORKS_TEMPLATES_DIR overrides; falls back to the built-in package templates/
; directory so that a valid (non-empty) document is always created.
procedure(softworksTemplatesRoot()
  "Returns the template root dir: SOFTWORKS_TEMPLATES_DIR if set, else built-in package templates/."
  let(((td getShellEnvVar("SOFTWORKS_TEMPLATES_DIR")))
    cond(
      ((and (neq stringp(td) nil) (greaterp strlen(td) 0)) td)
      ((equal 0 0) strcat(SoftworksInstallDir "/templates")))))

procedure(softworksBlankDocTemplatePath(relativeTemplatePath "t")
  "Full path to a template file under the active template root."
  strcat(softworksTemplatesRoot() "/" relativeTemplatePath))

; Create a cell view and populate it from the matching blank template.
; Returns the writePath string on success, nil on failure.
; relTemplatePath e.g. "xlsx/xlsxTemplate.xlsx" — resolved via softworksBlankDocTemplatePath.
procedure(softworksCreateDocViewFromTemplate(lname cellName viewName viewFileName relTemplatePath)
  let(((viewObj ddGetObj(lname cellName viewName viewFileName nil "w"))
       (templatePath nil)
       (sourcePath nil))
    cond(
      ((eq viewObj nil)
       warn("Softworks: cannot create cell view %s %s %s %s" lname cellName viewName viewFileName)
       nil)
      ((equal 0 0)
       templatePath = softworksBlankDocTemplatePath(relTemplatePath)
       sourcePath = cond(
         ((neq isReadable(templatePath) t)
          warn("Softworks: template %s not found; using built-in." templatePath)
          strcat(SoftworksInstallDir "/templates/" car(reverse(parseString(relTemplatePath "/")))))
         ((equal 0 0) templatePath))
       shell(strcat("cp -f " sourcePath " " viewObj~>writePath))
       ddUpdateLibList()
       viewObj~>writePath))))

; Default directory for documentation import GUIs (PPTX/PDF/etc. file picker start path).
; SOFTWORKS_DOCS_IMPORT_DIR overrides; otherwise <effective project root>/doc/ (warn if both override env vars unset).
procedure(softworksProjectDocDir()
  "Returns a directory path ending in / for the documentation import file picker default."
  let(((explicit getShellEnvVar("SOFTWORKS_DOCS_IMPORT_DIR"))
       (root nil))
    if(explicit && greaterp(strlen(explicit) 0) then
      strcat(explicit "/")
    else
      progn(
	root = softworksEffectiveProjectRoot()
	if(getShellEnvVar("SOFTWORKS_PROJECT_ROOT") then
	  strcat(root "/doc/")
	else
	  progn(
	    warn(sprintf(nil
	      "Softworks: SOFTWORKS_DOCS_IMPORT_DIR and SOFTWORKS_PROJECT_ROOT are not set; using the default doc import path %s/doc/ (current working directory as project root)."
	      pwd()))
	    strcat(root "/doc/")
	  )
	)
      )
    )
  )
)

; Launch an external viewer/editor on one file. ipcBeginProcess does its own
; tokenizing: it drops double quotes and splits at spaces, and expands $VARS
; (even inside single quotes), so a path cannot be quoted on its command line.
; The path travels in SOFTWORKS_LAUNCH_FILE instead and bin/launch_with_file.sh
; appends it as one argument. prefix: program and its options, e.g.
; "libreoffice --writer" (no path, no $). Limitation: setShellEnvVar expands a
; literal $NAME inside the path itself.
procedure(launchWithFile(prefix filePath)
  setShellEnvVar("SOFTWORKS_LAUNCH_FILE" filePath)
  ipcBeginProcess(strcat("sh " SoftworksInstallDir "/bin/launch_with_file.sh " prefix) "" nil nil))

; Alist/VrtImport *->* accessors can be nil on some builds; NewDocViewGUI and others need these
; globals to be real procedures. Value-cell assignment is not enough in SKILL++: calls like
; softworksProjectDocDir() use the function obarray; use putd to register the funobj.
SdmIdleTrigger = IdleTrigger
SdmLaunchWithFile = launchWithFile
softworksProjectDocDir = softworksProjectDocDir
SoftworksProjectDocDir = softworksProjectDocDir
softworksEffectiveProjectRoot = softworksEffectiveProjectRoot
SoftworksEffectiveProjectRoot = softworksEffectiveProjectRoot
softworksTemplatesRoot = softworksTemplatesRoot
SoftworksTemplatesRoot = softworksTemplatesRoot
softworksBlankDocTemplatePath = softworksBlankDocTemplatePath
SoftworksBlankDocTemplatePath = softworksBlankDocTemplatePath
softworksCreateDocViewFromTemplate = softworksCreateDocViewFromTemplate
SoftworksCreateDocViewFromTemplate = softworksCreateDocViewFromTemplate
putd('SdmIdleTrigger IdleTrigger)
putd('SdmLaunchWithFile launchWithFile)
putd('softworksProjectDocDir softworksProjectDocDir)
putd('SoftworksProjectDocDir softworksProjectDocDir)
putd('softworksEffectiveProjectRoot softworksEffectiveProjectRoot)
putd('SoftworksEffectiveProjectRoot softworksEffectiveProjectRoot)
putd('softworksTemplatesRoot softworksTemplatesRoot)
putd('SoftworksTemplatesRoot softworksTemplatesRoot)
putd('softworksBlankDocTemplatePath softworksBlankDocTemplatePath)
putd('SoftworksBlankDocTemplatePath softworksBlankDocTemplatePath)
putd('softworksCreateDocViewFromTemplate softworksCreateDocViewFromTemplate)
putd('SoftworksCreateDocViewFromTemplate softworksCreateDocViewFromTemplate)
list(nil
	'IdleTrigger IdleTrigger
	'startGedit startGedit
	'deRegSdmApp deRegSdmApp
	'initDeRegApp initDeRegApp
	'uninitDeRegApp uninitDeRegApp
	'softworksProjectDocDir softworksProjectDocDir
	'softworksEffectiveProjectRoot softworksEffectiveProjectRoot
	'softworksTemplatesRoot softworksTemplatesRoot
	'softworksBlankDocTemplatePath softworksBlankDocTemplatePath
	'softworksCreateDocViewFromTemplate softworksCreateDocViewFromTemplate
))

Softworks = VrtImport['Package]->New('Softworks
              ?module Softworks
              ?description module_description
              ; DEBASE: never wrap kw value as (SoftworksInstallDirFromPiport()) — outer () applies return value as functor.
              ?project_init_dir_path SoftworksInstallDirFromPiport())
)
; SdmIdleTrigger and softworks* globals are set on the alist before list() above; do not
; rebind from VrtImport['Softworks]->* here (can be nil and break GUICellView / defValue).

; Safe documentation import default directory for contexts where calling
; softworksProjectDocDir() fails ("not a function - nil" with HI ?defValue / SKILL++).
; Mirrors env/root/pwd logic using getShellEnvVar / strcat / pwd only — no d().
SoftworksDocImportPathResult = nil

procedure(SoftworksDocPathStore(v)
  SoftworksDocImportPathResult = v)

procedure(SoftworksDocPathApplyPwdDocWarn()
  warn(sprintf(nil
    "Softworks: SOFTWORKS_DOCS_IMPORT_DIR and SOFTWORKS_PROJECT_ROOT are not set; using the default doc import path %s/doc/ (current working directory as project root)."
    pwd()))
  SoftworksDocPathStore(strcat(pwd() "/doc/")))

; Returns t when SOFTWORKS_DOCS_IMPORT_DIR yields a usable path (side effect: stores path).
procedure(SoftworksDocPathFillFromDocEnvVarCore()
  cond(
    ((equal nil getShellEnvVar("SOFTWORKS_DOCS_IMPORT_DIR")) nil)
    (equal(strlen(getShellEnvVar("SOFTWORKS_DOCS_IMPORT_DIR")) 0) nil)
    (t
      SoftworksDocPathStore(strcat(getShellEnvVar("SOFTWORKS_DOCS_IMPORT_DIR") "/"))
      t)))

; Returns t when SOFTWORKS_PROJECT_ROOT yields a usable path (side effect: stores path).
procedure(SoftworksDocPathFillFromRootEnvVarCore()
  cond(
    ((equal nil getShellEnvVar("SOFTWORKS_PROJECT_ROOT")) nil)
    (equal(strlen(getShellEnvVar("SOFTWORKS_PROJECT_ROOT")) 0) nil)
    (t
      SoftworksDocPathStore(strcat(getShellEnvVar("SOFTWORKS_PROJECT_ROOT") "/doc/"))
      t)))

procedure(SoftworksDocPathFillFromEnv()
  cond(
    ((neq SoftworksDocPathFillFromDocEnvVarCore() nil) nil)
    ((neq SoftworksDocPathFillFromRootEnvVarCore() nil) nil)
    (t SoftworksDocPathApplyPwdDocWarn())))

procedure(SoftworksInvokeProjectDocDir()
  SoftworksDocPathFillFromEnv()
  SoftworksDocImportPathResult)

putd('SoftworksInvokeProjectDocDir SoftworksInvokeProjectDocDir)

printf("done\n")
