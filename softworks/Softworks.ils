printf("  Loading Softworks core...")

let((Softworks
  (module_description "Software and documentation view types in the Cadence Virtuoso IC design environment"))

Softworks = let(()

; A trigger that does nothing and is commonly used for the app and enable triggers.
procedure(IdleTrigger(@optional argList)
	;Do Nothing
	t)

; Open a view in the gedit text editor
procedure(startGedit(@rest restArgs)
	if(restArgs then
		system(sprintf(nil "gedit %s &" buildString(restArgs)))
	else
		system("gedit &"))
)

procedure(deRegSdmApp(viewType appName dataTrigger @optional (parentType nil))
	cond(
	(member(viewType deGetAllViewTypes())
		warn("Already defined the \"%s\" view type, need to run uninit before redefining it." viewType))
	(dataTrigger
		deRegApp( ; Primary type
	    	?appName appName
	    	?enableTrigger 'SdmIdleTrigger
	    	?dataTrigger stringToSymbol(dataTrigger)
	    	?viewType viewType
			?appTrigger 'SdmIdleTrigger
	    	?widgetType "none"
	  	)
	)
	(parentType ; subtype
		deRegApp(
	    	?appName appName
	    	?enableTrigger 'SdmIdleTrigger
	    	?parentType parentType
	    	?viewType viewType
	    	?widgetType "none"
	  	)
	)
	(t warn("Either the dataTrigger or parentType must be specified for view type" viewType)))
)

; Initialize All the custom cellviews contained in viewSetup
;  viewSetup is a list with each element containing the definition for a view witht the form:
;   list(viewType  appName dataTrigger parentType)
procedure(initDeRegApp(viewSetup) let(((out t))
	foreach(app viewSetup
			out = out && deRegSdmApp(car(app) cadr(app) caddr(app) cadddr(app))
	)
	out
))

; uninitialize all Python views so they can be redefined
procedure(uninitDeRegApp(viewSetup) let(((out t))
	foreach(view viewSetup
		when(member(car(view) deGetAllViewTypes())
			out = out && deUnRegApp(car(view)))
	)
	out
))

; Effective project root: SOFTWORKS_PROJECT_ROOT when set, else pwd().
procedure(softworksEffectiveProjectRoot()
  let((r))
  r = getShellEnvVar("SOFTWORKS_PROJECT_ROOT")
  if(r then
    r
  else
    pwd())
)

; Default directory for documentation import GUIs (PPTX/PDF/etc. file picker start path).
; SOFTWORKS_DOC_DIR overrides; otherwise <SOFTWORKS_PROJECT_ROOT or pwd>/doc/ (warn if project root unset).
procedure(softworksProjectDocDir()
  let((root explicit))
  explicit = getShellEnvVar("SOFTWORKS_DOC_DIR")
  if(explicit && greaterp(strlen(explicit) 0) then
    strcat(explicit "/")
  else
    progn(
      root = softworksEffectiveProjectRoot()
      if(getShellEnvVar("SOFTWORKS_PROJECT_ROOT") then
	strcat(root "/doc/")
      else
	progn(
	  warn(sprintf(nil
	    "Softworks: SOFTWORKS_DOC_DIR and SOFTWORKS_PROJECT_ROOT are not set; using the default doc import path %s/doc/ (current working directory as project root)."
	    pwd()))
	  strcat(root "/doc/")
	)
      )
    )
  )
)

list(nil
	'IdleTrigger IdleTrigger
	'startGedit startGedit
	'deRegSdmApp deRegSdmApp
	'initDeRegApp initDeRegApp
	'uninitDeRegApp uninitDeRegApp
	'softworksProjectDocDir softworksProjectDocDir
	'softworksEffectiveProjectRoot softworksEffectiveProjectRoot
))

Softworks = VrtImport['Module]->New('Softworks
              ?module Softworks
              ?package Softworks
              ?description module_description)
)
; Global Functions
SdmIdleTrigger = VrtImport['Softworks]->IdleTrigger
SoftworksProjectDocDir = VrtImport['Softworks]->softworksProjectDocDir
SoftworksEffectiveProjectRoot = VrtImport['Softworks]->softworksEffectiveProjectRoot

printf("done\n")
