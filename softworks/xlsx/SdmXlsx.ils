printf("  Loading XLSX support...")

let((XLSX
	(module_description "Adds a Excel (*.xlsx) view type to Virtuoso")
	(Softworks Import['Softworks]))

XLSX = let((
	(viewSetup '(
	;(viewType  appName dataTrigger parentType)
	("xlsx" "libreoffice_xlsx" "SdmXLSXDataTrigger" nil)
	)))

; Register All XLSX Custom Cellviews
procedure(init() let(((out t))
	Softworks->initDeRegApp(viewSetup)
))

; uninitialize all XLSX views so they can be redefined
procedure(uninit() let(((out t))
	Softworks->uninitDeRegApp(viewSetup)
))

; Open a XLSX view with the function specified by startReader
;  startReader should start the editor with no arguments specified.
;  startReader should open any number of views when specified as additional arguments.
procedure(DataTrigger(@optional argList)
	if(not(argList) then
		warn("Softworks: SdmXLSXDataTrigger called with nil argList")
		t
	else
	let((libName cellName file fileName extension objId viewFileName viewName viewType appName
	     startReaderFn combinedGuiFn fileReadable)
	libName = argList->libName
	cellName = argList->cellName
    viewName = argList->viewName
	rootType = argList->rootType
	appName = argList->appName
	; viewFileId is a dd object on argList: use ~>name, not ->name (avoids "not a function - nil").
	viewFileName = let((vf)
	  vf = argList->viewFileId
	  if(not(vf) then argList->fileName
	  else if(stringp(vf) then vf
	  else vf~>name)))
	; Nested when (not and): must never evaluate Softworks->... when Softworks is nil.
	; Softworks is the outer-let binding (same object as Import['Softworks] at load).
	startReaderFn = when(Softworks
	  when(Softworks->XLSX
	    Softworks->XLSX->startReader))
	combinedGuiFn = when(Softworks
	  when(Softworks->NewDocViewGUI
	    Softworks->NewDocViewGUI->CombinedGUI))

	when(getd('getShellEnvVar)
	  when(getShellEnvVar("SOFTWORKS_DEBUG")
	    warn(sprintf(nil
	      "Softworks DEBUG: SdmXLSXDataTrigger enter lib=%L cell=%L view=%L viewFile=%L app=%L rootType=%L"
	      libName cellName viewName viewFileName appName rootType))))

	objId = when(getd('ddGetObj)
	  ddGetObj(libName cellName viewName viewFileName nil "r"))
	if(objId then
		; Open existing file
    	file = when(getd('ddGetObjWritePath) ddGetObjWritePath(objId))
	fileReadable = if(file then
	  if(getd('isFile) then isFile(file) else nil)
	else nil)
	when(getd('getShellEnvVar)
	  when(getShellEnvVar("SOFTWORKS_DEBUG")
	    warn(sprintf(nil
	      "Softworks DEBUG: SdmXLSXDataTrigger OPEN branch objId=%L file=%L fileReadable=%L"
	      objId file fileReadable))))
		; Start editor
		if(fileReadable then
			when(getd('getShellEnvVar)
			  when(getShellEnvVar("SOFTWORKS_DEBUG")
			    warn(sprintf(nil
			      "Softworks DEBUG: SdmXLSXDataTrigger calling XLSX->startReader app=%L file=%L"
			      appName file))))
			if(startReaderFn then
			  startReaderFn(appName file)
			else
			  warn("Softworks: XLSX or startReader is nil; reinstall/upgrade softworks and load order"))
		else
			warn("Warning, couldn't open %s / %s / %s as a XLSX view", libName cellName viewName))
	else
		when(getd('getShellEnvVar)
		  when(getShellEnvVar("SOFTWORKS_DEBUG")
		    warn(sprintf(nil
		      "Softworks DEBUG: SdmXLSXDataTrigger NEW branch -> NewDocViewGUI->CombinedGUI lib=%L cell=%L view=%L"
		      libName cellName viewName))))
		if(combinedGuiFn then
		  combinedGuiFn(libName cellName viewName)
		else
		  warn("Softworks: NewDocViewGUI or CombinedGUI is nil; check NewDocViewGUI.ils loaded"))
	)
	t
	)))

procedure(startReader(app filePath)
	system(strcat( "libreoffice --calc " filePath))
)

list(nil
	'init init
	'uninit uninit
	'DataTrigger DataTrigger
	'startReader startReader
))

putprop(Softworks XLSX 'XLSX)
XLSX->init()

)

;Global functions
SdmXLSXDataTrigger = Import['Softworks]->XLSX->DataTrigger

printf("done\n")
