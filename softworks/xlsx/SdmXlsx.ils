printf("  Loading XLSX support...")

; File-scope: nested-let procs (e.g. the old module startReader) are not safe to call from
; SdmXLSXDataTrigger; Virtuoso can report eval: not a function - nil on apply.
procedure(SdmXLSXStartReader(app filePath)
	system(strcat("libreoffice --calc " filePath)))

; DEBASE: ?dataTrigger must be file-scope; see SdmXLSXDataTrigger. Module 'DataTrigger uses
; this symbol. Load before XLSX->init() / deRegApp.
procedure(SdmXLSXDataTrigger(@optional argList)
	; Open a XLSX view with the function specified by startReader
	if(not(argList) then
		warn("Softworks: SdmXLSXDataTrigger called with nil argList")
		t
	else
	let((libName cellName file fileName extension objId viewFileName viewName viewType appName
	     fileReadable)
	libName = argList->libName
	cellName = argList->cellName
    viewName = argList->viewName
	rootType = argList->rootType
	appName = argList->appName
	; viewFileId is a dd object on argList: use ~>name, not ->name (avoids "not a function - nil").
	viewFileName = let((vf)
	  vf = argList->viewFileId
	  if(not(vf) then argList->fileName
	  else if(stringp(vf) then vf
	  else vf~>name)))

	when(getShellEnvVar("SOFTWORKS_DEBUG")
	  warn(sprintf(nil
	    "Softworks DEBUG: SdmXLSXDataTrigger enter lib=%L cell=%L view=%L viewFile=%L app=%L rootType=%L"
	    libName cellName viewName viewFileName appName rootType)))

	objId = ddGetObj(libName cellName viewName viewFileName nil "r")
	if(objId then
		; Open existing file
    	file = ddGetObjWritePath(objId)
	fileReadable = if(file then isFile(file) else nil)
	when(getShellEnvVar("SOFTWORKS_DEBUG")
	  warn(sprintf(nil
	    "Softworks DEBUG: SdmXLSXDataTrigger OPEN branch objId=%L file=%L fileReadable=%L"
	    objId file fileReadable)))
		; Start editor
		if(fileReadable then
			when(getShellEnvVar("SOFTWORKS_DEBUG")
			  warn(sprintf(nil
			    "Softworks DEBUG: SdmXLSXDataTrigger calling SdmXLSXStartReader app=%L file=%L"
			    appName file)))
			SdmXLSXStartReader(appName file)
		else
			warn("Warning, couldn't open %s / %s / %s as a XLSX view", libName cellName viewName))
	else
		when(getShellEnvVar("SOFTWORKS_DEBUG")
		  warn(sprintf(nil
		    "Softworks DEBUG: SdmXLSXDataTrigger NEW branch -> NewDocViewGUI->CombinedGUI lib=%L cell=%L view=%L"
		    libName cellName viewName)))
		if( (boundp('SdmCombinedGUI) && SdmCombinedGUI) then
		  SdmCombinedGUI(libName cellName viewName)
		else if( Import['Softworks] && Import['Softworks]->NewDocViewGUI
			 && Import['Softworks]->NewDocViewGUI->CombinedGUI) then
		  Import['Softworks]->NewDocViewGUI->CombinedGUI(libName cellName viewName)
		else
		  warn("Softworks: NewDocViewGUI/CombinedGUI unavailable; check NewDocViewGUI.ils load order"))
	)
	t
	)))

let((XLSX
	(module_description "Adds a Excel (*.xlsx) view type to Virtuoso")
	(Softworks Import['Softworks]))

XLSX = let((
	(viewSetup '(
	;(viewType  appName dataTrigger parentType)
	("xlsx" "libreoffice_xlsx" "SdmXLSXDataTrigger" nil)
	)))

; Register All XLSX Custom Cellviews
procedure(init() let(((out t))
	Softworks->initDeRegApp(viewSetup)
))

; uninitialize all XLSX views so they can be redefined
procedure(uninit() let(((out t))
	Softworks->uninitDeRegApp(viewSetup)
))

list(nil
	'init init
	'uninit uninit
	'DataTrigger SdmXLSXDataTrigger
	'startReader SdmXLSXStartReader
))

putprop(Softworks XLSX 'XLSX)
XLSX->init()

)

printf("done\n")
