printf("  Loading XLSX support...")

let((XLSX
	(module_description "Adds a Excel (*.xlsx) view type to Virtuoso")
	(Softworks Import['Softworks]))

XLSX = let((
	(viewSetup '(
	;(viewType  appName dataTrigger parentType)
	("xlsx" "libreoffice_xlsx" "SdmXLSXDataTrigger" nil)
	)))

; Register All XLSX Custom Cellviews
procedure(init() let(((out t))
	Softworks->initDeRegApp(viewSetup)
))

; uninitialize all XLSX views so they can be redefined
procedure(uninit() let(((out t))
	Softworks->uninitDeRegApp(viewSetup)
))

; Open a XLSX view with the function specified by startReader
;  startReader should start the editor with no arguments specified.
;  startReader should open any number of views when specified as additional arguments.
procedure(DataTrigger(@optional argList)
	if(not(argList) then
		warn("Softworks: SdmXLSXDataTrigger called with nil argList")
		t
	else
	let((libName cellName file fileName extension objId viewFileName viewName viewType appName
	     startReaderFn combinedGuiFn)
	libName = argList->libName
	cellName = argList->cellName
    viewName = argList->viewName
	rootType = argList->rootType
	appName = argList->appName
	viewFileName = if(argList->viewFileId then argList->viewFileId->name else nil)
	; Resolve callables without chaining past nil (-> on nil => "not a function - nil")
	startReaderFn = when(and(Import['Softworks] Import['Softworks]->XLSX)
	  Import['Softworks]->XLSX->startReader)
	combinedGuiFn = when(and(Import['Softworks] Import['Softworks]->NewDocViewGUI)
	  Import['Softworks]->NewDocViewGUI->CombinedGUI)

	when(getShellEnvVar("SOFTWORKS_DEBUG")
	  warn(sprintf(nil
	    "Softworks DEBUG: SdmXLSXDataTrigger enter lib=%L cell=%L view=%L viewFile=%L app=%L rootType=%L"
	    libName cellName viewName viewFileName appName rootType)))

    if( objId = ddGetObj(libName cellName viewName viewFileName nil "r") then
		; Open existing file
    	file = ddGetObjWritePath(objId)
	when(getShellEnvVar("SOFTWORKS_DEBUG")
	  warn(sprintf(nil
	    "Softworks DEBUG: SdmXLSXDataTrigger OPEN branch objId=%L file=%L isFile=%L"
	    objId file (isFile(file)))))
		; Start editor
		if(isFile(file) then
			when(getShellEnvVar("SOFTWORKS_DEBUG")
			  warn(sprintf(nil
			    "Softworks DEBUG: SdmXLSXDataTrigger calling XLSX->startReader app=%L file=%L"
			    appName file)))
			if(startReaderFn then
			  startReaderFn(appName file)
			else
			  warn("Softworks: XLSX or startReader is nil; reinstall/upgrade softworks and load order"))
		else
			warn("Warning, couldn't open %s / %s / %s as a XLSX view", libName cellName viewName))
	else
		when(getShellEnvVar("SOFTWORKS_DEBUG")
		  warn(sprintf(nil
		    "Softworks DEBUG: SdmXLSXDataTrigger NEW branch -> NewDocViewGUI->CombinedGUI lib=%L cell=%L view=%L"
		    libName cellName viewName)))
		if(combinedGuiFn then
		  combinedGuiFn(libName cellName viewName)
		else
		  warn("Softworks: NewDocViewGUI or CombinedGUI is nil; check NewDocViewGUI.ils loaded"))
	)
	t
	)))

procedure(startReader(app filePath)
	system(strcat( "libreoffice --calc " filePath))
)

list(nil
	'init init
	'uninit uninit
	'DataTrigger DataTrigger
	'startReader startReader
))

putprop(Softworks XLSX 'XLSX)
XLSX->init()

)

;Global functions
SdmXLSXDataTrigger = Import['Softworks]->XLSX->DataTrigger

printf("done\n")
