printf("  Loading Python support...")

; SdmPyDataTrigger: assign from procedure DataTrigger; Python->DataTrigger can be nil on some builds.

let((Python
	   (Softworks VrtImport['Softworks]))

Python = let((
	(viewSetup '(
	;(viewType  appName dataTrigger parentType)
	("module" "vscode_module" "SdmPyDataTrigger" nil)
		("module_gedit" "gedit_module" nil "module")
	("notebook" "vscode_notebook" "SdmPyDataTrigger" nil)
	("yaml" "vscode_yaml" "SdmPyDataTrigger" nil)
		("yaml_gedit" "gedit_yaml" nil "yaml")
	("toml" "vscode_toml" "SdmPyDataTrigger" nil)
	("markdown" "vscode_markdown" "SdmPyDataTrigger" nil)
		("markdown_gedit" "gedit_markdown" nil "markdown")
	)))

; Register All Python Custom Cellviews
procedure(init() let(((out t))
	Softworks->initDeRegApp(viewSetup)
))

; uninitialize all Python views so they can be redefined
procedure(uninit() let(((out t))
	Softworks->uninitDeRegApp(viewSetup)
))

; Open a python view with the function specified by startReader
;  startReader should start the editor with no arguments specified.
;  startReader should open any number of views when specified as additional arguments.
procedure(DataTrigger(@optional argList)
	if(not(argList) then
		warn("Softworks: SdmPyDataTrigger called with nil argList")
		t
	else
	let((libName cellName viewName rootType appName viewFileName
		   userWorkspacePath file_workspace_link_path
		   filePath fileName extension objId templateName softworks_root_path)
	libName  = argList->libName
	cellName = argList->cellName
	viewName = argList->viewName
	rootType = argList->rootType
	appName  = argList->appName
	; viewFileId is a dd object: use ~>name, not ->name (avoids "not a function - nil").
	viewFileName = let((vf)
	  vf = argList->viewFileId
	  if(not(vf) then argList->fileName
	  else if(stringp(vf) then vf
	  else vf~>name)))

	userWorkspacePath = if(getShellEnvVar("SOFTWORKS_VSCODE_WORKSPACE") then
	  getShellEnvVar("SOFTWORKS_VSCODE_WORKSPACE")
	else
	  strcat(softworksEffectiveProjectRoot() "/softworks_workspace"))
	unless(getShellEnvVar("SOFTWORKS_VSCODE_WORKSPACE")
	  warn(sprintf(nil
	    "Softworks: SOFTWORKS_VSCODE_WORKSPACE is not set; using %s for Python view paths."
	    userWorkspacePath)))

	; Open existing file through the workspace symbolic link or else the direct path.
	if(objId = ddGetObj(libName cellName viewName viewFileName nil "r") then
		filePath = ddGetObjWritePath(objId)
		; viewFileName may be nil when DEBASE omits fileName/viewFileId; resolve from path.
		when(not(viewFileName)
		  viewFileName = car(reverse(parseString(filePath "/"))))
		file_workspace_link_path = if(viewFileName then
		  strcat(userWorkspacePath "/" libName "/" cellName "/" viewName "/" viewFileName)
		else nil)
		let(((py VrtImport['Softworks]->Python))
		  cond(
		    ((eq py nil)
		     warn("[Softworks Python] Python module not loaded; cannot open editor."))
		    ((not(procedurep(py->startReader)))
		     warn("[Softworks Python] startReader is not a procedure; cannot open editor."))
		    ((isFile(file_workspace_link_path))
		     py->startReader(appName file_workspace_link_path))
		    ((isFile(filePath))
		     py->startReader(appName filePath))
		    ((equal 0 0)
		     warn("Warning, couldn't open %s / %s / %s as a Python view"
		          libName cellName viewName))))
	else
		; Create a new file by copying a template.
		extension = case(rootType
			("module"   ".py")
			("notebook" ".ipynb")
			("yaml"     ".yaml")
			("toml"     ".toml")
			("markdown" ".md")
			("rst"      ".rst")
			(t          ".py"))
		templateName = strcat(rootType "Template" extension)
		fileName = strcat(viewName extension)
		if(objId = ddGetObj(libName cellName viewName fileName nil "w") then
		  filePath = ddGetObjWritePath(objId)
		  system(sprintf(nil "cp %s/templates/%s %s" SoftworksInstallDir templateName filePath))
		  let(((py VrtImport['Softworks]->Python))
		    cond(
		      ((eq py nil)
		       warn("[Softworks Python] Python module not loaded; cannot open editor."))
		      ((neq procedurep(py->startReader) nil)
		       py->startReader(appName filePath))
		      ((equal 0 0)
		       warn("[Softworks Python] startReader is not a procedure; cannot open editor."))))
		else
		  warn("Could not create the cellview file %s / %s / %s / %s"
		       libName cellName viewName fileName))
	)
	t
	)))

SdmPyDataTrigger = DataTrigger
putd('SdmPyDataTrigger SdmPyDataTrigger)
unless(procedurep(SdmPyDataTrigger)
  warn(sprintf(nil
    "[Softworks Python] FATAL: SdmPyDataTrigger is not a procedure after bind (value=%L); DEBASE triggers will fail."
    SdmPyDataTrigger)))

procedure(startReader(app filePath)
  case(app
    (("vscode_module" "vscode_notebook" "vscode_yaml" "vscode_markdown" "vscode_toml")
      if(procedurep(SdmVsCodeOpen) then
        SdmVsCodeOpen(filePath)
      else
        warn("[Softworks Python] SdmVsCodeOpen is not bound; cannot open editor.")))
    (("gedit_module" "gedit_yaml" "gedit_markdown")
      let(((sg Softworks->startGedit))
        cond(
          ((neq procedurep(sg) nil) sg(filePath))
          ((equal 0 0)
           warn("[Softworks Python] Softworks->startGedit is not a procedure; cannot open editor.")))))
  )
)

list(nil
	'init init
	'uninit uninit
	'DataTrigger DataTrigger
	'startReader startReader
))

putprop(Softworks Python 'Python)
Python->init()

)

printf("done\n")
