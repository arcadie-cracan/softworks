printf("  Loading Python support...")

; Defined before Python->init() / deRegApp so ?dataTrigger is not nil at registration.
procedure(SdmPyDataTrigger(@optional argList)
	when(Import['Softworks]
	  when(Import['Softworks]->Python
	    Import['Softworks]->Python->DataTrigger(argList))))

let((Python
	   (Softworks Import['Softworks]))

Python = let((
	(viewSetup '(
	;(viewType  appName dataTrigger parentType)
	("module" "vscode_module" "SdmPyDataTrigger" nil)
		("module_gedit" "gedit_module" nil "module")
	("notebook" "vscode_notebook" "SdmPyDataTrigger" nil)
	("yaml" "vscode_yaml" "SdmPyDataTrigger" nil)
		("yaml_gedit" "gedit_yaml" nil "yaml")
	("toml" "vscode_toml" "SdmPyDataTrigger" nil)
	("markdown" "vscode_markdown" "SdmPyDataTrigger" nil)
		("markdown_gedit" "gedit_markdown" nil "markdown")
	)))

; Register All Python Custom Cellviews
procedure(init() let(((out t))
	Softworks->initDeRegApp(viewSetup)
))

; uninitialize all Python views so they can be redefined
procedure(uninit() let(((out t))
	Softworks->uninitDeRegApp(viewSetup)
))

; Open a python view with the function specified by startReader
;  startReader should start the editor with no arguments specified.
;  startReader should open any number of views when specified as additional arguments.
procedure(DataTrigger(@optional argList)
	let((libName cellName viewName rootType appName viewFileName
		   userName userWorkspacePath file_workspace_link_path
		   filePath fileName extension objId templateName softworks_root_path)
	libName = argList->libName
	cellName = argList->cellName
  viewName = argList->viewName
	rootType = argList->rootType
	appName = argList->appName
	viewFileName = argList->viewFileId->name

  userName = getShellEnvVar("USER")

  userWorkspacePath = if(getShellEnvVar("SOFTWORKS_VSCODE_WORKSPACE") then
    getShellEnvVar("SOFTWORKS_VSCODE_WORKSPACE")
  else
    strcat(Softworks->softworksEffectiveProjectRoot() "/softworks_workspace")
  )
  unless(getShellEnvVar("SOFTWORKS_VSCODE_WORKSPACE")
    warn(sprintf(nil
      "Softworks: SOFTWORKS_VSCODE_WORKSPACE is not set; using %s for Python view paths."
      userWorkspacePath))
  )
	; Open existing file through the workspace symbolic link or else the direct path
  if( objId = ddGetObj(libName cellName viewName viewFileName nil "r") then
		file_workspace_link_path = strcat(userWorkspacePath "/" libName "/" cellName "/" viewName "/" viewFileName)
    filePath = ddGetObjWritePath(objId)
		if(isFile(file_workspace_link_path) then
		  Import['Softworks]->Python->startReader(appName file_workspace_link_path)
		else if(isFile(filePath) then
			Import['Softworks]->Python->startReader(appName filePath)
		else
			warn("Warning, couldn't open %s / %s / %s as a Python view",
			     libName cellName viewName)))
	else
		; Create a new file by copying a template
		extension = case(rootType
			("module"   ".py")
			("notebook" ".ipynb")
			("yaml"     ".yaml")
      ("toml"     ".toml")
			("markdown" ".md")
			("rst" 		".rst")
			(t 			".py") ; default
		)
		templateName = strcat(rootType "Template" extension)
		fileName = strcat(cellName extension)

		if(objId = ddGetObj(libName cellName viewName fileName nil "w") then
		  filePath = ddGetObjWritePath(objId)
      softworks_root_path = Import['Package]->GetPackageMetadata(Import['Softworks])['project_root_path]
			system(sprintf(nil "cp %s/python/%s %s" softworks_root_path templateName filePath))
			Import['Softworks]->Python->startReader(appName filePath)
		else
			warn("Could not create the cellview file %s / %s / %s / %s"
			     libName cellName viewName fileName))
	)
	t
))

procedure(startReader(app filePath)
  case(app
    (("vscode_module" "vscode_notebook" "vscode_yaml" "vscode_markdown" "vscode_toml")
      Import['VsCode]->open(filePath))
    (("gedit_module" "gedit_yaml" "gedit_markdown")
      Softworks->startGedit(filePath))
  )
)

list(nil
	'init init
	'uninit uninit
	'DataTrigger DataTrigger
	'startReader startReader
))

putprop(Softworks Python 'Python)
Python->init()

)

printf("done\n")
