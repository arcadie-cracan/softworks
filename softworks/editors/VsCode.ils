printf("  Loading VS Code support...")
let((VsCode
	(module_description "Visual Studio Code")
	(Path VrtImport['Path])
	(Module VrtImport['Module])
	(Str VrtImport['Str])
  (Softworks VrtImport['Softworks])
  )

VsCode =let((VsCodeProcess )

procedure(open(@optional (filePath "") "t")
  "Start VS Code and open the filePath if specified"
  let((wp cli prefix cmd vscProc ud ext extra)
    ; --- resolve workspace path ---
    wp = getShellEnvVar("SOFTWORKS_VSCODE_WORKSPACE")
    unless(wp
      wp = strcat(softworksEffectiveProjectRoot() "/softworks_workspace")
      warn(sprintf(nil
        "Softworks: SOFTWORKS_VSCODE_WORKSPACE is not set; using %s for VS Code." wp)))
    unless(strlen(wp) >= 16 && zerop(strcmp(substring(wp -16) ".code-workspace"))
      unless(isReadable(wp) createDirHier(wp)))
    ; --- resolve VS Code binary ---
    cli = getShellEnvVar("SOFTWORKS_VSCODE_CLI")
    unless(cli cli = "code")
    ; --- build extra CLI flags ---
    prefix = ""
    ud = getShellEnvVar("SOFTWORKS_VSCODE_USER_DATA_DIR")
    ext = getShellEnvVar("SOFTWORKS_VSCODE_EXTENSIONS_DIR")
    extra = getShellEnvVar("SOFTWORKS_VSCODE_EXTRA_ARGS")
    when(ud    prefix = strcat(prefix sprintf(nil " --user-data-dir \"%s\""  ud)))
    when(ext   prefix = strcat(prefix sprintf(nil " --extensions-dir \"%s\"" ext)))
    when(extra prefix = strcat(prefix " " extra))
    ; --- build the shell command ---
    printf("VS Code: Opening %s in %s workspace\n" filePath wp)
    cmd = strcat("exec " cli prefix " "
      if(strlen(wp) >= 16 && zerop(strcmp(substring(wp -16) ".code-workspace")) then
        wp
      else
        strcat("--add " wp)))
    unless(!stringp(filePath) || zerop(strlen(filePath))
      cmd = strcat(cmd " " filePath))
    cmd = strcat(cmd "; exit")
    printf("VS Code: %s\n" cmd)
    vscProc = ipcBeginProcess(cmd "" nil nil)
    unless(when(VsCodeProcess ipcIsActiveProcess(VsCodeProcess))
      VsCodeProcess = vscProc)
  )
)

procedure(StartLmgrCB(_MenuName _Lib _Cell _View _a _b)
	open()
)

list(nil
	'name "VS Code"
	'open open
	'openFile open
	'StartLmgrCB StartLmgrCB
))

VsCode = Module->New('VsCode
  ?module VsCode
  ?parent Softworks
  ?description module_description)
Module->AddFunction(Softworks 'VsCode VsCode)

; Must be inside the let where VsCode is in scope.
SdmVsCodeOpen = VsCode->open
putd('SdmVsCodeOpen SdmVsCodeOpen)
SdmVsCodeStartLmgrCB = VsCode->StartLmgrCB
unless(procedurep(SdmVsCodeOpen)
  warn(sprintf(nil
    "[Softworks VsCode] FATAL: SdmVsCodeOpen is not a procedure after bind (value=%L); Python/notebook editor will not open."
    SdmVsCodeOpen)))
unless(procedurep(SdmVsCodeStartLmgrCB)
  warn(sprintf(nil
    "[Softworks VsCode] FATAL: SdmVsCodeStartLmgrCB is not a procedure after bind (value=%L); LMgr menu will not work."
    SdmVsCodeStartLmgrCB)))
)

printf("done\n")
