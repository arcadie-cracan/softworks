printf("  Loading VS Code support...")
let((VsCode
	(module_description "Visual Studio Code")
	(Path Import['Path])
	(Module Import['Module])
	(Str Import['Str])
  (Softworks Import['Softworks])
  )

VsCode =let((VsCodeProcess )

procedure(workspace_path_is_code_workspace_file_p(p "t")
  p
  && (strlen(p) >= 16)
  && zerop(strcmp(substring(p -16) ".code-workspace"))
)

procedure(open(@optional (filePath "") "t")
  "Start VS Code and open the filePath if specified"
  let((cmd process
       (workspace_path
         let(((wp (getShellEnvVar("SOFTWORKS_VSCODE_WORKSPACE"))))
           unless(wp
             wp = Path->Cat(Softworks->softworksEffectiveProjectRoot() "softworks_workspace")
             warn(sprintf(nil
               "Softworks: SOFTWORKS_VSCODE_WORKSPACE is not set; using %s for VS Code."
               wp)))
           unless(workspace_path_is_code_workspace_file_p(wp)
             unless(isReadable(wp)
               createDirHier(wp)))
           wp))
       (cli
         let(((bin (getShellEnvVar("SOFTWORKS_VSCODE_CLI"))))
           if(bin then bin else "code"))
       )
       (prefix
         let(((ud  (getShellEnvVar("SOFTWORKS_VSCODE_USER_DATA_DIR")))
              (ext (getShellEnvVar("SOFTWORKS_VSCODE_EXTENSIONS_DIR")))
              extra
              (s   ""))
           when(ud
             s = strcat(s sprintf(nil " --user-data-dir \"%s\"" ud)))
           when(ext
             s = strcat(s sprintf(nil " --extensions-dir \"%s\"" ext)))
           extra = getShellEnvVar("SOFTWORKS_VSCODE_EXTRA_ARGS")
           when(extra
             s = strcat(s " " extra))
           s)
       )
      )
    print_message(sprintf(nil "Opening %s in %s workspace" filePath workspace_path))
    cmd = strcat("exec " cli prefix " "
      if(workspace_path_is_code_workspace_file_p(workspace_path) then
        workspace_path
      else
        strcat("--add " workspace_path)))
    unless(Str->emptyp(filePath)
      cmd = strcat(cmd " " filePath))
    cmd = strcat(cmd "; exit")
    print_message(cmd)
    process = ipcBeginProcess(cmd ""
      outputCallback
      errorCallback)
    unless(isActive()
      VsCodeProcess = process)
  )
)

procedure(outputCallback(o_childId t_data)
  "Echo all of the stdout from VS Code in the CIW"
	if(t_data == sprintf(nil "VScode exited\n") then
		stop()
	else
		print_message(t_data))
)

procedure(errorCallback(o_childId t_data)
"Echo all of the stderr from VS Code in the CIW as a warning"
	warn("VS Code: %s" t_data))

procedure(exitCallback(o_childId x_exitStatus)
  "Called when VS Code exits"
	print_message("VS Code Exited")
	VsCodeProcess = nil
)

procedure(StartLmgrCB(_MenuName _Lib _Cell _View _a _b)
	open())

procedure(print_message(message "t")
	printf("VS Code: %s\n" message)
)

procedure(isActive()
  when(VsCodeProcess
    ipcIsActiveProcess(VsCodeProcess))
)

list(nil
	'name "VS Code"
	'open open
	'openFile open
	'StartLmgrCB StartLmgrCB
))

VsCode = Module->New('VsCode
  ?module VsCode
  ?package Softworks
  ?description module_description)
Module->AddFunction(Softworks 'VsCode VsCode)
)

; Library Manager Menu Callbacks
SdmVsCodeStartLmgrCB = Import['Softworks]->VsCode->StartLmgrCB

printf("done\n")
