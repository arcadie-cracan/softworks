printf("  Loading VS Code support...")
let((VsCode
	(module_description "Visual Studio Code")
	(Path Import['Path])
	(Module Import['Module])
	(Str Import['Str])
  (Softworks Import['Softworks])
  )

VsCode =let((VsCodeProcess )

procedure(open(@optional (filePath "") "t")
  "Start VS Code and open the filePath if specified"
  let((wp cli prefix cmd vscProc)
    printf("open: A filePath=%s\n" filePath)
    wp = getShellEnvVar("SOFTWORKS_VSCODE_WORKSPACE")
    printf("open: B wp=%s\n" wp)
    unless(wp
      wp = strcat(Softworks->softworksEffectiveProjectRoot() "/softworks_workspace")
      warn(sprintf(nil
        "Softworks: SOFTWORKS_VSCODE_WORKSPACE is not set; using %s for VS Code." wp)))
    printf("open: C\n")
    unless(strlen(wp) >= 16 && zerop(strcmp(substring(wp -16) ".code-workspace"))
      unless(isReadable(wp) createDirHier(wp)))
    printf("open: D\n")
    cli = getShellEnvVar("SOFTWORKS_VSCODE_CLI")
    printf("open: E cli=%s\n" cli)
    unless(cli cli = "code")
    printf("open: F cli=%s\n" cli)
    prefix = ""
    printf("open: G\n")
    let(((ud  (getShellEnvVar("SOFTWORKS_VSCODE_USER_DATA_DIR")))
         (ext (getShellEnvVar("SOFTWORKS_VSCODE_EXTENSIONS_DIR")))
         extra)
      printf("open: H ud=%s\n" ud)
      when(ud  prefix = strcat(prefix sprintf(nil " --user-data-dir \"%s\""  ud)))
      printf("open: I prefix=%s\n" prefix)
      when(ext prefix = strcat(prefix sprintf(nil " --extensions-dir \"%s\"" ext)))
      printf("open: J prefix=%s\n" prefix)
      extra = getShellEnvVar("SOFTWORKS_VSCODE_EXTRA_ARGS")
      printf("open: K extra=%s\n" extra)
      when(extra prefix = strcat(prefix " " extra)))
    printf("open: L prefix=%s\n" prefix)
    printf("VS Code: Opening %s in %s workspace\n" filePath wp)
    cmd = strcat("exec " cli prefix " "
      if(strlen(wp) >= 16 && zerop(strcmp(substring(wp -16) ".code-workspace")) then
        wp
      else
        strcat("--add " wp)))
    printf("open: M cmd=%s\n" cmd)
    unless(!stringp(filePath) || zerop(strlen(filePath))
      cmd = strcat(cmd " " filePath))
    cmd = strcat(cmd "; exit")
    printf("VS Code: %s\n" cmd)
    vscProc = ipcBeginProcess(cmd "" nil nil)
    unless(when(VsCodeProcess ipcIsActiveProcess(VsCodeProcess))
      VsCodeProcess = vscProc)
  )
)

procedure(StartLmgrCB(_MenuName _Lib _Cell _View _a _b)
	open()
)

list(nil
	'name "VS Code"
	'open open
	'openFile open
	'StartLmgrCB StartLmgrCB
))

VsCode = Module->New('VsCode
  ?module VsCode
  ?package Softworks
  ?description module_description)
Module->AddFunction(Softworks 'VsCode VsCode)
)

; Library Manager Menu Callbacks
SdmVsCodeStartLmgrCB = Import['Softworks]->VsCode->StartLmgrCB

; Diagnostic: confirm registration at load time
printf("VsCode load: Import['VsCode]=%L  Import['Softworks]->VsCode=%L\n"
  Import['VsCode] Import['Softworks]->VsCode)

printf("done\n")
