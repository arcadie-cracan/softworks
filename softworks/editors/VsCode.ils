printf("  Loading VS Code support...")
let((VsCode
	(module_description "Visual Studio Code")
	(Path Import['Path])
	(Module Import['Module])
	(Str Import['Str])
  (Softworks Import['Softworks])
  )

VsCode =let((VsCodeProcess )

procedure(open(@optional (filePath "") "t")
  "Start VS Code and open the filePath if specified"
  let((wp cli prefix cmd vscProc)
    ; --- resolve workspace path ---
    wp = getShellEnvVar("SOFTWORKS_VSCODE_WORKSPACE")
    unless(wp
      wp = strcat(Softworks->softworksEffectiveProjectRoot() "/softworks_workspace")
      warn(sprintf(nil
        "Softworks: SOFTWORKS_VSCODE_WORKSPACE is not set; using %s for VS Code." wp)))
    unless(strlen(wp) >= 16 && zerop(strcmp(substring(wp -16) ".code-workspace"))
      unless(isReadable(wp) createDirHier(wp)))
    ; --- resolve VS Code binary ---
    cli = getShellEnvVar("SOFTWORKS_VSCODE_CLI")
    unless(cli cli = "code")
    ; --- build extra CLI flags ---
    prefix = ""
    let(((ud  (getShellEnvVar("SOFTWORKS_VSCODE_USER_DATA_DIR")))
         (ext (getShellEnvVar("SOFTWORKS_VSCODE_EXTENSIONS_DIR")))
         extra)
      when(ud  prefix = strcat(prefix sprintf(nil " --user-data-dir \"%s\""  ud)))
      when(ext prefix = strcat(prefix sprintf(nil " --extensions-dir \"%s\"" ext)))
      extra = getShellEnvVar("SOFTWORKS_VSCODE_EXTRA_ARGS")
      when(extra prefix = strcat(prefix " " extra)))
    ; --- build the shell command ---
    printf("VS Code: Opening %s in %s workspace\n" filePath wp)
    cmd = strcat("exec " cli prefix " "
      if(strlen(wp) >= 16 && zerop(strcmp(substring(wp -16) ".code-workspace")) then
        wp
      else
        strcat("--add " wp)))
    unless(!stringp(filePath) || zerop(strlen(filePath))
      cmd = strcat(cmd " " filePath))
    cmd = strcat(cmd "; exit")
    printf("VS Code: %s\n" cmd)
    vscProc = ipcBeginProcess(cmd "" nil nil)
    unless(when(VsCodeProcess ipcIsActiveProcess(VsCodeProcess))
      VsCodeProcess = vscProc)
  )
)

procedure(StartLmgrCB(_MenuName _Lib _Cell _View _a _b)
	open()
)

list(nil
	'name "VS Code"
	'open open
	'openFile open
	'StartLmgrCB StartLmgrCB
))

VsCode = Module->New('VsCode
  ?module VsCode
  ?package Softworks
  ?description module_description)
Module->AddFunction(Softworks 'VsCode VsCode)
)

; Library Manager Menu Callbacks
SdmVsCodeStartLmgrCB = Import['Softworks]->VsCode->StartLmgrCB

; Diagnostic: confirm registration at load time
printf("VsCode load: Import['VsCode]=%L  Import['Softworks]->VsCode=%L\n"
  Import['VsCode] Import['Softworks]->VsCode)

printf("done\n")
