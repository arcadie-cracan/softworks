printf("  Loading VS Code support...")
let((VsCode
	(module_description "Visual Studio Code")
	(Path Import['Path])
	(Module Import['Module])
	(Str Import['Str])
  (Softworks Import['Softworks])
  )

VsCode =let((VsCodeProcess )

procedure(workspace_path_is_code_workspace_file_p(p "t")
  p
  && (strlen(p) >= 16)
  && zerop(strcmp(substring(p -16) ".code-workspace"))
)

; Optional VS Code CLI flags (same idea as shell alias "command code --user-data-dir …").
; Set SOFTWORKS_VSCODE_USER_DATA_DIR and SOFTWORKS_VSCODE_EXTENSIONS_DIR in the environment.
; If unset, no extra flags are passed (VS Code uses its normal defaults for user-data/extensions).
procedure(vscode_code_cli()
  let(((bin (getShellEnvVar("SOFTWORKS_VSCODE_CLI"))))
    if(bin then bin else "code"))
)

procedure(vscode_code_prefix_args()
  let(((ud  (getShellEnvVar("SOFTWORKS_VSCODE_USER_DATA_DIR")))
       (ext (getShellEnvVar("SOFTWORKS_VSCODE_EXTENSIONS_DIR")))
       extra
       (s   ""))
    when(ud
      s = strcat(s sprintf(nil " --user-data-dir \"%s\"" ud)))
    when(ext
      s = strcat(s sprintf(nil " --extensions-dir \"%s\"" ext)))
    extra = getShellEnvVar("SOFTWORKS_VSCODE_EXTRA_ARGS")
    when(extra
      s = strcat(s " " extra))
    s)
)

procedure(open(@optional (filePath "") "t")
  "Start VS Code and open the filePath if specified"
  let((cmd process workspace_path cli prefix)
    printf("VsCode: open called filePath=%s\n" filePath)
    workspace_path = setup_workspace()
    printf("VsCode: workspace_path=%s\n" workspace_path)
    cli = vscode_code_cli()
    printf("VsCode: cli=%s\n" cli)
    prefix = vscode_code_prefix_args()
    printf("VsCode: prefix=%s\n" prefix)
    print_message(sprintf(nil "Opening %s in %s workspace" filePath workspace_path))
    cmd = strcat("exec " cli prefix " "
      if(workspace_path_is_code_workspace_file_p(workspace_path) then
        workspace_path
      else
        strcat("--add " workspace_path)))
    printf("VsCode: cmd after workspace=%s\n" cmd)
    unless(Str->emptyp(filePath)
      cmd = strcat(cmd " " filePath))
    cmd = strcat(cmd "; exit")
    print_message(cmd)
    process = ipcBeginProcess(cmd ""
      outputCallback
      errorCallback)
    unless(isActive()
      VsCodeProcess = process)
  )
)

procedure(outputCallback(o_childId t_data)
  "Echo all of the stdout from VS Code in the CIW"
	if(t_data == sprintf(nil "VScode exited\n") then
		stop()
	else
		print_message(t_data))
)

procedure(errorCallback(o_childId t_data)
"Echo all of the stderr from VS Code in the CIW as a warning"
	warn("VS Code: %s" t_data))

procedure(exitCallback(o_childId x_exitStatus)
  "Called when VS Code exits"
	print_message("VS Code Exited")
	VsCodeProcess = nil
)

procedure(setup_workspace()
  "Returns the VS Code workspace path from SOFTWORKS_VSCODE_WORKSPACE (directory or .code-workspace file)."
  let(((workspace_path (getShellEnvVar("SOFTWORKS_VSCODE_WORKSPACE"))))
    unless(workspace_path
      workspace_path = Path->Cat(Softworks->softworksEffectiveProjectRoot() "softworks_workspace")
      warn(sprintf(nil
        "Softworks: SOFTWORKS_VSCODE_WORKSPACE is not set; using %s for VS Code."
        workspace_path))
    )
    if(workspace_path_is_code_workspace_file_p(workspace_path) then
      workspace_path
    else
      progn(
        unless(isReadable(workspace_path)
          createDirHier(workspace_path))
        workspace_path
      )
    )
  )
)

procedure(StartLmgrCB(_MenuName _Lib _Cell _View _a _b)
	open())

procedure(print_message(message "t")
	printf("VS Code: %s\n" message)
)

procedure(isActive()
  when(VsCodeProcess
    ipcIsActiveProcess(VsCodeProcess))
)

list(nil
	'name "VS Code"
	'open open
	'openFile open
	'StartLmgrCB StartLmgrCB
))

VsCode = Module->New('VsCode
  ?module VsCode
  ?package Softworks
  ?description module_description)
Module->AddFunction(Softworks 'VsCode VsCode)
)

; Library Manager Menu Callbacks
SdmVsCodeStartLmgrCB = Import['Softworks]->VsCode->StartLmgrCB

printf("done\n")
