let((EditorModule
	(module_description "Editor modules are modules with a 'name property and an 'open function. They also include a default DataTrigger.")
	(Project VrtImport['IDS]->Project)
	(Path VrtImport['Path])
	(Module VrtImport['Module])
	(Str VrtImport['Str])
	(Softworks VrtImport['Softworks])
	)

EditorModule =let((EditorModuleState )

procedure(New(module_symbol @key module parent (description ""))
	"Registers a new editor module and adds a DataTrigger function to it."
	module = Module->New(module_symbol
		?module module
		?parent parent
		?description description)

	Module->AddFunction(module 'DataTrigger
		lambda((argList) DataTrigger(module argList)))
	module
)

; Open a view using the editor module's open method.
; If the view file cannot be found, the new-view GUI is shown instead.
procedure(DataTrigger(module @optional argList)
	"Open a view using the open method of the specified editor module."
	let((file fileName objId
		(libName  argList->libName)
		(cellName argList->cellName)
		(viewName argList->viewName)
		(rootType argList->rootType)
		(appName  argList->appName)
		(viewFileName argList->viewFileId->name))
		if(objId = ddGetObj(libName cellName viewName viewFileName nil "r") then
			file = ddGetObjWritePath(objId)
			if(isFile(file) then
				module->open(file)
			else
				warn("Softworks: could not open %s/%s/%s as an editor view."
					libName cellName viewName))
		else
			VrtImport['Softworks]->NewDocViewGUI->CombinedGUI(libName cellName viewName)
		)
		t
	)
)

list(nil
	'New New
	'DataTrigger DataTrigger
))

EditorModule = Module->New('EditorModule
	?module EditorModule
	?parent Softworks
	?description module_description)
Module->AddFunction(Softworks 'EditorModule EditorModule)
)
