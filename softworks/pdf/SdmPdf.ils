printf("  Loading PDF support...")

; Set SdmPdfDataTrigger to the procedure object here, not as PDF->DataTrigger: on some
; Virtuoso builds the alist "->" form returns nil, so init sees a non-function trigger.

let((PDF
	(Softworks VrtImport['Softworks]))

PDF = let((
	(viewSetup '(
	;(viewType  appName dataTrigger parentType)
	("pdf" "firefox_pdf" "SdmPdfDataTrigger" nil)
	)))

; Register All PDF Custom Cellviews
procedure(init() let(((out t))
	Softworks->initDeRegApp(viewSetup)
))

; Unregister Cellviews
procedure(uninit() let(((out t))
	Softworks->uninitDeRegApp(viewSetup)
))

procedure(startReader(filePath)
  let(((viewer or(getShellEnvVar("SOFTWORKS_PDF_VIEWER") "firefox")))
    ipcBeginProcess(strcat(viewer " " EscapeSpecialCharacters(filePath)) "" nil nil)))

; PDF is an import/open-only view type — PDFs are generated artifacts, not created blank.
; If the view does not exist, direct the user to the Library Manager import action.
procedure(DataTrigger(@optional argList)
	if(not(argList) then
		warn("Softworks: SdmPdfDataTrigger called with nil argList")
		t
	else
	let((libName cellName lname file fileReadable objId viewFileName viewName rootType)
	libName = argList->libName
	cellName = argList->cellName
	viewName = argList->viewName
	rootType = argList->rootType
	; viewFileId is a dd object on argList: use ~>name, not ->name (avoids "not a function - nil").
	viewFileName = let((vf)
	  vf = argList->viewFileId
	  if(not(vf) then argList->fileName
	  else if(stringp(vf) then vf
	  else vf~>name)))
	when(not(viewFileName)
	  viewFileName = ddMapGetViewTypeFileName(
	    if(argList->viewType then argList->viewType else argList->rootType)))
	when(not(viewFileName)
	  viewFileName = strcat(viewName ".pdf"))
	lname = if(argList->libId then argList->libId~>name else argList->libName)

	objId = if(viewFileName then ddGetObj(lname cellName viewName viewFileName nil "r") else nil)
	unless(objId
	  objId = ddGetObj(lname cellName viewName nil nil "r"))
	if(objId then
		file = ddGetObjWritePath(objId)
		fileReadable = if(file then isFile(file) else nil)
		if(fileReadable then
			let(((pdf VrtImport['Softworks]->PDF))
			  cond(
			    ((eq pdf nil)
			     warn("[Softworks PDF] PDF module not loaded; cannot open viewer."))
			    ((neq procedurep(pdf->startReader) nil)
			     pdf->startReader(file))
			    ((equal 0 0)
			     warn("[Softworks PDF] startReader is not a procedure; cannot open viewer."))))
		else
			warn("Warning, couldn't open %s / %s / %s as a PDF view" libName cellName viewName))
	else
		; No existing view — open the import dialog pre-filled with lib/cell/view.
		if(procedurep(SdmCreateViewFromFileGUI) then
			SdmCreateViewFromFileGUI(lname cellName viewName)
		else
			warn("[Softworks PDF] No PDF view found for %s %s %s. Use 'Import Document as Cell View' in the Library Manager to import a PDF."
			     libName cellName viewName)))
	t
	)))

SdmPdfDataTrigger = DataTrigger
putd('SdmPdfDataTrigger SdmPdfDataTrigger)
unless(procedurep(SdmPdfDataTrigger)
  warn(sprintf(nil
    "[Softworks PDF] FATAL: SdmPdfDataTrigger is not a procedure after bind (value=%L); DEBASE pdf trigger will fail."
    SdmPdfDataTrigger)))

list(nil
	'init init
	'uninit uninit
	'DataTrigger DataTrigger
	'startReader startReader
))

putprop(Softworks PDF 'PDF)
PDF->init()
unless(procedurep(SdmPdfDataTrigger)
  warn(sprintf(nil
    "[Softworks PDF] FATAL: SdmPdfDataTrigger lost procedure status after init (value=%L)."
    SdmPdfDataTrigger)))

)

printf("done\n")
