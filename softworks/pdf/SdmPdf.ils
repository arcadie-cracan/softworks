printf("  Loading PDF support...")

; Set SdmPdfDataTrigger to the procedure object here, not as PDF->DataTrigger: on some
; Virtuoso builds the alist "->" form returns nil, so init sees a non-function trigger.

let((PDF
	(Softworks VrtImport['Softworks]))

PDF = let((
	(viewSetup '(
	;(viewType  appName dataTrigger parentType)
	("pdf" "evince_pdf" "SdmPdfDataTrigger" nil)
	)))

; Register All PDF Custom Cellviews
procedure(init() let(((out t))
	Softworks->initDeRegApp(viewSetup)
	; Register Firefox as a secondary "Open With" option using the parentType mechanism.
	; "pdf_firefox" is a sub-viewType of "pdf"; LMgr lists sub-type apps under "Open With".
	deRegApp(
		?viewType      "pdf_firefox"
		?parentType    "pdf"
		?appName       "firefox_pdf"
		?dataTrigger   'SdmPdfFirefoxDataTrigger
		?enableTrigger 'SdmIdleTrigger
		?appTrigger    'SdmIdleTrigger
	)
	out
))

; Unregister Cellviews
procedure(uninit() let(((out t))
	Softworks->uninitDeRegApp(viewSetup)
	when(member("pdf_firefox" deGetAllViewTypes())
		deUnRegApp("pdf_firefox"))
	out
))

; Launch the PDF file with an explicit viewer command.
; Shared by all dispatch paths in DataTrigger.
procedure(openPdfWith(viewer argList)
  if(not(argList) then
    warn("Softworks: PDF open trigger called with nil argList")
    t
  else
  let((libName cellName lname file fileReadable objId viewFileName viewName rootType)
  libName  = argList->libName
  cellName = argList->cellName
  viewName = argList->viewName
  rootType = argList->rootType
  ; viewFileId is a dd object on argList: use ~>name, not ->name.
  viewFileName = let((vf)
    vf = argList->viewFileId
    if(not(vf) then argList->fileName
    else if(stringp(vf) then vf
    else vf~>name)))
  when(not(viewFileName)
    viewFileName = ddMapGetViewTypeFileName(
      if(argList->viewType then argList->viewType else argList->rootType)))
  when(not(viewFileName)
    viewFileName = strcat(viewName ".pdf"))
  lname = if(argList->libId then argList->libId~>name else argList->libName)

  objId = if(viewFileName then ddGetObj(lname cellName viewName viewFileName nil "r") else nil)
  unless(objId
    objId = ddGetObj(lname cellName viewName nil nil "r"))
  if(objId then
    file = ddGetObjWritePath(objId)
    fileReadable = if(file then isFile(file) else nil)
    if(fileReadable then
      ipcBeginProcess(strcat(viewer " \"" file "\"") "" nil nil)
    else
      warn("Warning, couldn't open %s / %s / %s as a PDF view" libName cellName viewName))
  else
    ; No existing view — open the import dialog pre-filled with lib/cell/view.
    if(procedurep(SdmCreateViewFromFileGUI) then
      SdmCreateViewFromFileGUI(lname cellName viewName)
    else
      warn("[Softworks PDF] No PDF view found for %s %s %s. Use 'Import Document as Cell View' in the Library Manager to import a PDF."
           libName cellName viewName)))
  t
  )))

; Default trigger: double-click on a pdf view. Uses SOFTWORKS_PDF_VIEWER or evince.
procedure(DataTrigger(@optional argList)
  openPdfWith(or(getShellEnvVar("SOFTWORKS_PDF_VIEWER") "evince") argList))

; Called when user selects "Open With: firefox_pdf" from LMgr context menu.
procedure(FirefoxDataTrigger(@optional argList)
  openPdfWith("firefox" argList))

procedure(startReader(filePath)
  let(((viewer or(getShellEnvVar("SOFTWORKS_PDF_VIEWER") "evince")))
    ipcBeginProcess(strcat(viewer " \"" filePath "\"") "" nil nil)))

SdmPdfDataTrigger = DataTrigger
putd('SdmPdfDataTrigger SdmPdfDataTrigger)
unless(procedurep(SdmPdfDataTrigger)
  warn(sprintf(nil
    "[Softworks PDF] FATAL: SdmPdfDataTrigger is not a procedure after bind (value=%L); DEBASE pdf trigger will fail."
    SdmPdfDataTrigger)))

SdmPdfFirefoxDataTrigger = FirefoxDataTrigger
putd('SdmPdfFirefoxDataTrigger SdmPdfFirefoxDataTrigger)

list(nil
	'init init
	'uninit uninit
	'DataTrigger DataTrigger
	'FirefoxDataTrigger FirefoxDataTrigger
	'startReader startReader
))

putprop(Softworks PDF 'PDF)
PDF->init()
unless(procedurep(SdmPdfDataTrigger)
  warn(sprintf(nil
    "[Softworks PDF] FATAL: SdmPdfDataTrigger lost procedure status after init (value=%L)."
    SdmPdfDataTrigger)))

)

printf("done\n")
