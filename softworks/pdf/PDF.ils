printf("  Loading PDF support...")

; Defined before PDF->init() / deRegApp so ?dataTrigger is not nil at registration.
procedure(SdmPdfDataTrigger(@optional argList)
	when(Import['Softworks]
	  when(Import['Softworks]->PDF
	    Import['Softworks]->PDF->DataTrigger(argList))))

let((PDF
	(Softworks Import['Softworks]))

PDF = let((
	(viewSetup '(
	;(viewType  appName dataTrigger parentType)
	("pdf_view" "firefox_pdf" "SdmPdfDataTrigger" nil)
	)))

; Register All PDF Custom Cellviews
procedure(init() let(((out t))
	Softworks->initDeRegApp(viewSetup)
))

; Unregister Cellviews
procedure(uninit() let(((out t))
	Softworks->uninitDeRegApp(viewSetup)
))

; Open a pdf view with the function specified by startReader
;  startReader should start the editor with no arguments specified.
;  startReader should open any number of views when specified as additional arguments.
procedure(DataTrigger(@optional argList )
	let(( libName cellName file fileName extension objId viewFileName viewName viewType appName)
	; printf("Calling SkyVer Power Point View Data Trigger on %L !\n", argList);
	libName = argList->libName
	cellName = argList->cellName
    viewName = argList->viewName
	rootType = argList->rootType
	appName = argList->appName
	viewFileName = argList->viewFileId->name

	if( objId = ddGetObj(libName cellName viewName viewFileName nil "r") then
        ; Open existing file
    	file = ddGetObjWritePath(objId)
		; Start editor
		if(isFile(file) then
			Import['Softworks]->PDF->startReader(appName file)
		else
			warn("Warning, couldn't open %s / %s / %s as a PDF view", libName cellName viewName))
	else
		; Create a new file by copying a template
		Import['Softworks]->NewDocViewGUI->CombinedGUI(libName cellName viewName)
	)
	t
))

procedure(startReader(app filePath)
	system(strcat( "firefox " filePath))
)

list(nil
	'init init
	'uninit uninit
	'DataTrigger DataTrigger
	'startReader startReader
))

putprop(Softworks PDF 'PDF)
PDF->init()

)

printf("done\n")
