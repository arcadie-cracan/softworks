printf("  Loading Skill support...")

; Defined before Skill->init() / deRegApp so ?dataTrigger is not nil at registration.
procedure(SdmSkillDataTrigger(@optional argList)
	when(Import['Softworks]
	  when(Import['Softworks]->Skill
	    Import['Softworks]->Skill->DataTrigger(argList))))

procedure(SdmSkillppDataTrigger(@optional argList)
	when(Import['Softworks]
	  when(Import['Softworks]->Skill
	    Import['Softworks]->Skill->DataTrigger(argList))))

let((Skill
	  (Softworks Import['Softworks]))

Skill = let((
	(viewSetup '(
	;(viewType  appName dataTrigger parentType)
	("skill"   "skillIde"   "SdmSkillDataTrigger" nil)
	("skillpp" "skillppIde" "SdmSkillppDataTrigger" nil)
	)))

procedure(startIDE(@rest restArgs)
	if(restArgs then
		ilgRunSKILLIDE(?fileList restArgs)
	else
		ilgRunSKILLIDE())
)

procedure(DataTrigger(@optional argList)
	let((libName cellName file fileName extension objId viewFileName viewName viewType softworks_root_path)
	;printf("Calling SkyVer  View App Trigger on %L !\n", argList);
	libName = argList->libName
	cellName = argList->cellName
    viewName = argList->viewName
    viewType = argList->viewType
	rootType = argList->rootType
   ;viewFileName = ddMapGetViewTypeFileName( rootType )
	viewFileName = argList->viewFileId->name

    if( objId = ddGetObj(libName cellName viewName viewFileName nil "r") then
    	file = ddGetObjWritePath(objId)
		;printf("filename = %s\n" fileName)
		; Start Editor
		if(isFile(file) then
			startIDE(file)
		else
			warn("Error opening %s / %s / %s", libName cellName viewName))
	else
		extension = case(viewType
			("skill"   ".il")
			("skillpp" ".ils")
			(t ".ils")
		)
		templateName = strcat(viewType "Template" extension)
		fileName = strcat(cellName extension)

		if(objId = ddGetObj(libName cellName viewName fileName nil "w") then
			file = ddGetObjWritePath(objId)
      softworks_root_path = Import['Package]->GetPackageMetadata(Import['Softworks])['project_root_path]
			system(sprintf(nil "cp %s/skill/%s %s" softworks_root_path templateName file))
			ddReleaseObj(objId)
			startIDE(file)
		else
			warn("Could not create the cellview %s / %s / %s, File: %s", libName cellName viewName fileName))
	)
	t
))

; initialize the SdmSkill views
procedure(init()
	Softworks->initDeRegApp(viewSetup)
)

; uninitialize the SdmSkill views so they can be redefined
procedure(uninit()
	deUnRegApp("skill")
	deUnRegApp("skillpp")
)

list(nil
	'startIDE startIDE
	'DataTrigger DataTrigger
	'init init
	'uninit uninit
))
putprop(Import['Softworks] Skill 'Skill)
Skill->init()

)

;Global functions
SdmStartSkillIde = Import['Softworks]->Skill->startIDE

printf("done\n")
